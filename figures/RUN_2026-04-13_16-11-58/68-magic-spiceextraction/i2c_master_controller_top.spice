* NGSPICE file created from i2c_master_controller_top.ext - technology: sky130A

* Black-box entry subcircuit for sky130_fd_sc_hd__fill_2 abstract view
.subckt sky130_fd_sc_hd__fill_2 VGND VNB VPB VPWR
.ends

* Black-box entry subcircuit for sky130_fd_sc_hd__fill_1 abstract view
.subckt sky130_fd_sc_hd__fill_1 VGND VNB VPB VPWR
.ends

* Black-box entry subcircuit for sky130_fd_sc_hd__decap_3 abstract view
.subckt sky130_fd_sc_hd__decap_3 VGND VNB VPB VPWR
.ends

* Black-box entry subcircuit for sky130_fd_sc_hd__dfrtp_2 abstract view
.subckt sky130_fd_sc_hd__dfrtp_2 CLK D RESET_B VGND VNB VPB VPWR Q
.ends

* Black-box entry subcircuit for sky130_fd_sc_hd__o21a_2 abstract view
.subckt sky130_fd_sc_hd__o21a_2 A1 A2 B1 VGND VNB VPB VPWR X
.ends

* Black-box entry subcircuit for sky130_fd_sc_hd__tapvpwrvgnd_1 abstract view
.subckt sky130_fd_sc_hd__tapvpwrvgnd_1 VGND VPWR
.ends

* Black-box entry subcircuit for sky130_fd_sc_hd__clkdlybuf4s25_1 abstract view
.subckt sky130_fd_sc_hd__clkdlybuf4s25_1 A VGND VNB VPB VPWR X
.ends

* Black-box entry subcircuit for sky130_fd_sc_hd__dlygate4sd3_1 abstract view
.subckt sky130_fd_sc_hd__dlygate4sd3_1 A VGND VNB VPB VPWR X
.ends

* Black-box entry subcircuit for sky130_fd_sc_hd__and3_2 abstract view
.subckt sky130_fd_sc_hd__and3_2 A B C VGND VNB VPB VPWR X
.ends

* Black-box entry subcircuit for sky130_fd_sc_hd__mux2_1 abstract view
.subckt sky130_fd_sc_hd__mux2_1 A0 A1 S VGND VNB VPB VPWR X
.ends

* Black-box entry subcircuit for sky130_fd_sc_hd__a22o_2 abstract view
.subckt sky130_fd_sc_hd__a22o_2 A1 A2 B1 B2 VGND VNB VPB VPWR X
.ends

* Black-box entry subcircuit for sky130_fd_sc_hd__nand2_2 abstract view
.subckt sky130_fd_sc_hd__nand2_2 A B VGND VNB VPB VPWR Y
.ends

* Black-box entry subcircuit for sky130_fd_sc_hd__dfxtp_2 abstract view
.subckt sky130_fd_sc_hd__dfxtp_2 CLK D VGND VNB VPB VPWR Q
.ends

* Black-box entry subcircuit for sky130_fd_sc_hd__conb_1 abstract view
.subckt sky130_fd_sc_hd__conb_1 VGND VNB VPB VPWR HI LO
.ends

* Black-box entry subcircuit for sky130_fd_sc_hd__clkbuf_4 abstract view
.subckt sky130_fd_sc_hd__clkbuf_4 A VGND VNB VPB VPWR X
.ends

* Black-box entry subcircuit for sky130_fd_sc_hd__and4_2 abstract view
.subckt sky130_fd_sc_hd__and4_2 A B C D VGND VNB VPB VPWR X
.ends

* Black-box entry subcircuit for sky130_fd_sc_hd__and2_2 abstract view
.subckt sky130_fd_sc_hd__and2_2 A B VGND VNB VPB VPWR X
.ends

* Black-box entry subcircuit for sky130_fd_sc_hd__nor2_2 abstract view
.subckt sky130_fd_sc_hd__nor2_2 A B VGND VNB VPB VPWR Y
.ends

* Black-box entry subcircuit for sky130_fd_sc_hd__xnor2_2 abstract view
.subckt sky130_fd_sc_hd__xnor2_2 A B VGND VNB VPB VPWR Y
.ends

* Black-box entry subcircuit for sky130_fd_sc_hd__dfstp_2 abstract view
.subckt sky130_fd_sc_hd__dfstp_2 CLK D SET_B VGND VNB VPB VPWR Q
.ends

* Black-box entry subcircuit for sky130_fd_sc_hd__and3b_2 abstract view
.subckt sky130_fd_sc_hd__and3b_2 A_N B C VGND VNB VPB VPWR X
.ends

* Black-box entry subcircuit for sky130_fd_sc_hd__a21o_2 abstract view
.subckt sky130_fd_sc_hd__a21o_2 A1 A2 B1 VGND VNB VPB VPWR X
.ends

* Black-box entry subcircuit for sky130_fd_sc_hd__clkbuf_8 abstract view
.subckt sky130_fd_sc_hd__clkbuf_8 A VGND VNB VPB VPWR X
.ends

* Black-box entry subcircuit for sky130_fd_sc_hd__clkbuf_2 abstract view
.subckt sky130_fd_sc_hd__clkbuf_2 A VGND VNB VPB VPWR X
.ends

* Black-box entry subcircuit for sky130_fd_sc_hd__or2_2 abstract view
.subckt sky130_fd_sc_hd__or2_2 A B VGND VNB VPB VPWR X
.ends

* Black-box entry subcircuit for sky130_fd_sc_hd__o21ai_2 abstract view
.subckt sky130_fd_sc_hd__o21ai_2 A1 A2 B1 VGND VNB VPB VPWR Y
.ends

* Black-box entry subcircuit for sky130_fd_sc_hd__nor3_2 abstract view
.subckt sky130_fd_sc_hd__nor3_2 A B C VGND VNB VPB VPWR Y
.ends

* Black-box entry subcircuit for sky130_fd_sc_hd__a2bb2o_2 abstract view
.subckt sky130_fd_sc_hd__a2bb2o_2 A1_N A2_N B1 B2 VGND VNB VPB VPWR X
.ends

* Black-box entry subcircuit for sky130_fd_sc_hd__a31o_2 abstract view
.subckt sky130_fd_sc_hd__a31o_2 A1 A2 A3 B1 VGND VNB VPB VPWR X
.ends

* Black-box entry subcircuit for sky130_fd_sc_hd__a21oi_2 abstract view
.subckt sky130_fd_sc_hd__a21oi_2 A1 A2 B1 VGND VNB VPB VPWR Y
.ends

* Black-box entry subcircuit for sky130_fd_sc_hd__or4_2 abstract view
.subckt sky130_fd_sc_hd__or4_2 A B C D VGND VNB VPB VPWR X
.ends

* Black-box entry subcircuit for sky130_fd_sc_hd__a211oi_2 abstract view
.subckt sky130_fd_sc_hd__a211oi_2 A1 A2 B1 C1 VGND VNB VPB VPWR Y
.ends

* Black-box entry subcircuit for sky130_fd_sc_hd__clkbuf_16 abstract view
.subckt sky130_fd_sc_hd__clkbuf_16 A VGND VNB VPB VPWR X
.ends

* Black-box entry subcircuit for sky130_fd_sc_hd__or4b_2 abstract view
.subckt sky130_fd_sc_hd__or4b_2 A B C D_N VGND VNB VPB VPWR X
.ends

* Black-box entry subcircuit for sky130_fd_sc_hd__or3_2 abstract view
.subckt sky130_fd_sc_hd__or3_2 A B C VGND VNB VPB VPWR X
.ends

* Black-box entry subcircuit for sky130_fd_sc_hd__inv_2 abstract view
.subckt sky130_fd_sc_hd__inv_2 A VGND VNB VPB VPWR Y
.ends

* Black-box entry subcircuit for sky130_fd_sc_hd__nand2b_2 abstract view
.subckt sky130_fd_sc_hd__nand2b_2 A_N B VGND VNB VPB VPWR Y
.ends

* Black-box entry subcircuit for sky130_fd_sc_hd__and2b_2 abstract view
.subckt sky130_fd_sc_hd__and2b_2 A_N B VGND VNB VPB VPWR X
.ends

* Black-box entry subcircuit for sky130_fd_sc_hd__a21bo_2 abstract view
.subckt sky130_fd_sc_hd__a21bo_2 A1 A2 B1_N VGND VNB VPB VPWR X
.ends

* Black-box entry subcircuit for sky130_fd_sc_hd__ebufn_2 abstract view
.subckt sky130_fd_sc_hd__ebufn_2 A TE_B VGND VNB VPB VPWR Z
.ends

* Black-box entry subcircuit for sky130_fd_sc_hd__clkinv_2 abstract view
.subckt sky130_fd_sc_hd__clkinv_2 A VGND VNB VPB VPWR Y
.ends

* Black-box entry subcircuit for sky130_fd_sc_hd__buf_2 abstract view
.subckt sky130_fd_sc_hd__buf_2 A VGND VNB VPB VPWR X
.ends

* Black-box entry subcircuit for sky130_fd_sc_hd__o31a_2 abstract view
.subckt sky130_fd_sc_hd__o31a_2 A1 A2 A3 B1 VGND VNB VPB VPWR X
.ends

* Black-box entry subcircuit for sky130_fd_sc_hd__a211o_2 abstract view
.subckt sky130_fd_sc_hd__a211o_2 A1 A2 B1 C1 VGND VNB VPB VPWR X
.ends

* Black-box entry subcircuit for sky130_fd_sc_hd__o32a_2 abstract view
.subckt sky130_fd_sc_hd__o32a_2 A1 A2 A3 B1 B2 VGND VNB VPB VPWR X
.ends

* Black-box entry subcircuit for sky130_fd_sc_hd__a2111o_2 abstract view
.subckt sky130_fd_sc_hd__a2111o_2 A1 A2 B1 C1 D1 VGND VNB VPB VPWR X
.ends

* Black-box entry subcircuit for sky130_fd_sc_hd__o21ba_2 abstract view
.subckt sky130_fd_sc_hd__o21ba_2 A1 A2 B1_N VGND VNB VPB VPWR X
.ends

* Black-box entry subcircuit for sky130_fd_sc_hd__a221o_2 abstract view
.subckt sky130_fd_sc_hd__a221o_2 A1 A2 B1 B2 C1 VGND VNB VPB VPWR X
.ends

* Black-box entry subcircuit for sky130_fd_sc_hd__xor2_2 abstract view
.subckt sky130_fd_sc_hd__xor2_2 A B VGND VNB VPB VPWR X
.ends

* Black-box entry subcircuit for sky130_fd_sc_hd__a221oi_2 abstract view
.subckt sky130_fd_sc_hd__a221oi_2 A1 A2 B1 B2 C1 VGND VNB VPB VPWR Y
.ends

* Black-box entry subcircuit for sky130_fd_sc_hd__buf_1 abstract view
.subckt sky130_fd_sc_hd__buf_1 A VGND VNB VPB VPWR X
.ends

* Black-box entry subcircuit for sky130_fd_sc_hd__o221a_2 abstract view
.subckt sky130_fd_sc_hd__o221a_2 A1 A2 B1 B2 C1 VGND VNB VPB VPWR X
.ends

* Black-box entry subcircuit for sky130_fd_sc_hd__o2bb2a_2 abstract view
.subckt sky130_fd_sc_hd__o2bb2a_2 A1_N A2_N B1 B2 VGND VNB VPB VPWR X
.ends

* Black-box entry subcircuit for sky130_fd_sc_hd__a311o_2 abstract view
.subckt sky130_fd_sc_hd__a311o_2 A1 A2 A3 B1 C1 VGND VNB VPB VPWR X
.ends

* Black-box entry subcircuit for sky130_fd_sc_hd__o211a_2 abstract view
.subckt sky130_fd_sc_hd__o211a_2 A1 A2 B1 C1 VGND VNB VPB VPWR X
.ends

* Black-box entry subcircuit for sky130_fd_sc_hd__o2111a_2 abstract view
.subckt sky130_fd_sc_hd__o2111a_2 A1 A2 B1 C1 D1 VGND VNB VPB VPWR X
.ends

* Black-box entry subcircuit for sky130_fd_sc_hd__a32o_2 abstract view
.subckt sky130_fd_sc_hd__a32o_2 A1 A2 A3 B1 B2 VGND VNB VPB VPWR X
.ends

* Black-box entry subcircuit for sky130_fd_sc_hd__nand3_2 abstract view
.subckt sky130_fd_sc_hd__nand3_2 A B C VGND VNB VPB VPWR Y
.ends

* Black-box entry subcircuit for sky130_fd_sc_hd__nand4_2 abstract view
.subckt sky130_fd_sc_hd__nand4_2 A B C D VGND VNB VPB VPWR Y
.ends

* Black-box entry subcircuit for sky130_fd_sc_hd__o22a_2 abstract view
.subckt sky130_fd_sc_hd__o22a_2 A1 A2 B1 B2 VGND VNB VPB VPWR X
.ends

* Black-box entry subcircuit for sky130_fd_sc_hd__or3b_2 abstract view
.subckt sky130_fd_sc_hd__or3b_2 A B C_N VGND VNB VPB VPWR X
.ends

.subckt i2c_master_controller_top VGND VPWR i_byte_cnt_reg[0] i_byte_cnt_reg[1] i_byte_cnt_reg[2]
+ i_byte_cnt_reg[3] i_byte_cnt_reg[4] i_byte_cnt_reg[5] i_byte_cnt_reg[6] i_byte_cnt_reg[7]
+ i_clk i_clk_div_lsb[0] i_clk_div_lsb[1] i_clk_div_lsb[2] i_clk_div_lsb[3] i_clk_div_lsb[4]
+ i_clk_div_lsb[5] i_clk_div_lsb[6] i_clk_div_lsb[7] i_config_reg[0] i_config_reg[1]
+ i_config_reg[2] i_config_reg[3] i_config_reg[4] i_config_reg[5] i_mode_reg[0] i_mode_reg[1]
+ i_mode_reg[2] i_mode_reg[3] i_mode_reg[4] i_mode_reg[5] i_mode_reg[6] i_mode_reg[7]
+ i_rst_n i_slave_addr_reg[0] i_slave_addr_reg[1] i_slave_addr_reg[2] i_slave_addr_reg[3]
+ i_slave_addr_reg[4] i_slave_addr_reg[5] i_slave_addr_reg[6] i_transmit_data[0] i_transmit_data[1]
+ i_transmit_data[2] i_transmit_data[3] i_transmit_data[4] i_transmit_data[5] i_transmit_data[6]
+ i_transmit_data[7] io_scl io_sda o_cmd_status_reg[0] o_cmd_status_reg[1] o_cmd_status_reg[2]
+ o_cmd_status_reg[3] o_cmd_status_reg[4] o_cmd_status_reg[5] o_cmd_status_reg[6]
+ o_cmd_status_reg[7] o_int_n o_receive_data[0] o_receive_data[1] o_receive_data[2]
+ o_receive_data[3] o_receive_data[4] o_receive_data[5] o_receive_data[6] o_receive_data[7]
+ o_received_data_valid o_start_ack o_transmit_data_request
XFILLER_39_222 VGND VGND VPWR VPWR sky130_fd_sc_hd__fill_2
XFILLER_39_233 VGND VGND VPWR VPWR sky130_fd_sc_hd__fill_1
XFILLER_39_299 VGND VGND VPWR VPWR sky130_fd_sc_hd__decap_3
XFILLER_26_85 VGND VGND VPWR VPWR sky130_fd_sc_hd__decap_3
XFILLER_26_96 VGND VGND VPWR VPWR sky130_fd_sc_hd__decap_3
XFILLER_45_236 VGND VGND VPWR VPWR sky130_fd_sc_hd__decap_3
XFILLER_45_258 VGND VGND VPWR VPWR sky130_fd_sc_hd__decap_3
XFILLER_13_144 VGND VGND VPWR VPWR sky130_fd_sc_hd__decap_3
XFILLER_42_73 VGND VGND VPWR VPWR sky130_fd_sc_hd__decap_3
XFILLER_36_225 VGND VGND VPWR VPWR sky130_fd_sc_hd__decap_3
X_1270_ clkload6/A _1270_/D load_slew108/X VGND VGND VPWR VPWR _1270_/Q sky130_fd_sc_hd__dfrtp_2
XFILLER_51_206 VGND VGND VPWR VPWR sky130_fd_sc_hd__decap_3
XFILLER_51_228 VGND VGND VPWR VPWR sky130_fd_sc_hd__decap_3
X_0985_ _1019_/A1 _1019_/A2 _1019_/B1 VGND VGND VPWR VPWR _0985_/X sky130_fd_sc_hd__o21a_2
XTAP_TAPCELL_ROW_14_183 VGND VPWR sky130_fd_sc_hd__tapvpwrvgnd_1
Xfanout105 fanout106/X VGND VGND VPWR VPWR fanout105/X sky130_fd_sc_hd__clkdlybuf4s25_1
Xfanout116 fanout120/X VGND VGND VPWR VPWR fanout116/X sky130_fd_sc_hd__clkdlybuf4s25_1
Xfanout127 _1061_/B1 VGND VGND VPWR VPWR _1055_/B1 sky130_fd_sc_hd__clkdlybuf4s25_1
XFILLER_27_225 VGND VGND VPWR VPWR sky130_fd_sc_hd__decap_3
XTAP_TAPCELL_ROW_37_297 VGND VPWR sky130_fd_sc_hd__tapvpwrvgnd_1
XFILLER_10_114 VGND VGND VPWR VPWR sky130_fd_sc_hd__decap_3
XFILLER_10_147 VGND VGND VPWR VPWR sky130_fd_sc_hd__fill_1
XFILLER_50_283 VGND VGND VPWR VPWR sky130_fd_sc_hd__decap_3
Xhold170 _1168_/Q VGND VGND VPWR VPWR _0658_/A sky130_fd_sc_hd__dlygate4sd3_1
Xhold181 _1212_/Q VGND VGND VPWR VPWR _0576_/S sky130_fd_sc_hd__dlygate4sd3_1
Xhold192 _0643_/X VGND VGND VPWR VPWR _1149_/D sky130_fd_sc_hd__dlygate4sd3_1
XFILLER_18_214 VGND VGND VPWR VPWR sky130_fd_sc_hd__decap_3
XFILLER_37_73 VGND VGND VPWR VPWR sky130_fd_sc_hd__fill_2
XTAP_TAPCELL_ROW_28_253 VGND VPWR sky130_fd_sc_hd__tapvpwrvgnd_1
X_0770_ _1222_/Q _1223_/Q _0770_/C VGND VGND VPWR VPWR _0771_/C sky130_fd_sc_hd__and3_2
XTAP_TAPCELL_ROW_11_164 VGND VPWR sky130_fd_sc_hd__tapvpwrvgnd_1
X_1253_ _1259_/CLK _1253_/D _1061_/X VGND VGND VPWR VPWR _1253_/Q sky130_fd_sc_hd__dfrtp_2
XFILLER_24_228 VGND VGND VPWR VPWR sky130_fd_sc_hd__decap_3
X_1184_ _1192_/CLK _1184_/D fanout116/X VGND VGND VPWR VPWR _1184_/Q sky130_fd_sc_hd__dfrtp_2
XPHY_EDGE_ROW_20_Left_72 VGND VGND VPWR VPWR sky130_fd_sc_hd__decap_3
XFILLER_32_294 VGND VGND VPWR VPWR sky130_fd_sc_hd__fill_2
X_0968_ hold230/X _1278_/Q _0974_/S VGND VGND VPWR VPWR _0968_/X sky130_fd_sc_hd__mux2_1
X_0899_ _1175_/D _0896_/Y _0897_/X _1081_/Q VGND VGND VPWR VPWR _1109_/D sky130_fd_sc_hd__a22o_2
XTAP_TAPCELL_ROW_2_121 VGND VPWR sky130_fd_sc_hd__tapvpwrvgnd_1
XFILLER_15_228 VGND VGND VPWR VPWR sky130_fd_sc_hd__fill_2
XTAP_TAPCELL_ROW_25_234 VGND VPWR sky130_fd_sc_hd__tapvpwrvgnd_1
XFILLER_23_97 VGND VGND VPWR VPWR sky130_fd_sc_hd__decap_3
XFILLER_0_57 VGND VGND VPWR VPWR sky130_fd_sc_hd__decap_3
X_0822_ _0822_/A _0822_/B _0822_/C VGND VGND VPWR VPWR _1247_/D sky130_fd_sc_hd__and3_2
XFILLER_9_88 VGND VGND VPWR VPWR sky130_fd_sc_hd__decap_3
XFILLER_50_3 VGND VGND VPWR VPWR sky130_fd_sc_hd__decap_3
X_0753_ _1217_/Q _0780_/A VGND VGND VPWR VPWR _0755_/B sky130_fd_sc_hd__nand2_2
X_0684_ _0543_/Y _1172_/Q _1171_/Q hold199/X VGND VGND VPWR VPWR _0684_/X sky130_fd_sc_hd__a22o_2
X_1236_ _1236_/CLK _1236_/D _1044_/X VGND VGND VPWR VPWR _1236_/Q sky130_fd_sc_hd__dfrtp_2
XTAP_TAPCELL_ROW_39_304 VGND VPWR sky130_fd_sc_hd__tapvpwrvgnd_1
X_1167_ _1233_/CLK _1167_/D _1042_/B1 VGND VGND VPWR VPWR _1167_/Q sky130_fd_sc_hd__dfrtp_2
X_1098_ _1268_/CLK _1098_/D VGND VGND VPWR VPWR _1098_/Q sky130_fd_sc_hd__dfxtp_2
XFILLER_20_264 VGND VGND VPWR VPWR sky130_fd_sc_hd__decap_3
XFILLER_43_301 VGND VGND VPWR VPWR sky130_fd_sc_hd__decap_3
X_1289__129 VGND VGND VPWR VPWR _1289__129/HI _1289_/A sky130_fd_sc_hd__conb_1
XFILLER_11_220 VGND VGND VPWR VPWR sky130_fd_sc_hd__decap_3
XFILLER_50_62 VGND VGND VPWR VPWR sky130_fd_sc_hd__decap_3
XFILLER_15_6 VGND VGND VPWR VPWR sky130_fd_sc_hd__decap_3
XFILLER_46_161 VGND VGND VPWR VPWR sky130_fd_sc_hd__fill_2
Xload_slew96 fanout95/X VGND VGND VPWR VPWR load_slew96/X sky130_fd_sc_hd__clkbuf_4
X_1021_ _1027_/A1 _1027_/A2 _1027_/B1 VGND VGND VPWR VPWR _1021_/X sky130_fd_sc_hd__o21a_2
X_0805_ _1239_/Q _1240_/Q _1241_/Q _1242_/Q VGND VGND VPWR VPWR _0824_/B sky130_fd_sc_hd__and4_2
X_0736_ _0736_/A _1212_/D VGND VGND VPWR VPWR _1234_/D sky130_fd_sc_hd__and2_2
X_0667_ hold265/X _0545_/Y _0680_/A _0666_/X VGND VGND VPWR VPWR _1166_/D sky130_fd_sc_hd__a22o_2
X_0598_ _0598_/A _0598_/B VGND VGND VPWR VPWR _1133_/D sky130_fd_sc_hd__nor2_2
XFILLER_25_301 VGND VGND VPWR VPWR sky130_fd_sc_hd__decap_3
XFILLER_37_172 VGND VGND VPWR VPWR sky130_fd_sc_hd__decap_3
X_1219_ _1226_/CLK _1219_/D _1027_/X VGND VGND VPWR VPWR _1219_/Q sky130_fd_sc_hd__dfrtp_2
XFILLER_4_249 VGND VGND VPWR VPWR sky130_fd_sc_hd__decap_3
XFILLER_31_304 VGND VGND VPWR VPWR sky130_fd_sc_hd__decap_3
XFILLER_43_120 VGND VGND VPWR VPWR sky130_fd_sc_hd__decap_3
XFILLER_43_175 VGND VGND VPWR VPWR sky130_fd_sc_hd__decap_3
XFILLER_45_40 VGND VGND VPWR VPWR sky130_fd_sc_hd__decap_3
XPHY_EDGE_ROW_51_Left_103 VGND VGND VPWR VPWR sky130_fd_sc_hd__decap_3
XFILLER_13_3 VGND VGND VPWR VPWR sky130_fd_sc_hd__decap_3
XFILLER_19_172 VGND VGND VPWR VPWR sky130_fd_sc_hd__fill_2
XFILLER_19_194 VGND VGND VPWR VPWR sky130_fd_sc_hd__fill_1
XFILLER_34_197 VGND VGND VPWR VPWR sky130_fd_sc_hd__decap_3
X_1004_ _1063_/A1 _1063_/A2 _1064_/B1 VGND VGND VPWR VPWR _1004_/X sky130_fd_sc_hd__o21a_2
X_0719_ _1139_/Q _1209_/Q VGND VGND VPWR VPWR _0719_/Y sky130_fd_sc_hd__xnor2_2
XFILLER_25_175 VGND VGND VPWR VPWR sky130_fd_sc_hd__decap_3
XFILLER_15_54 VGND VGND VPWR VPWR sky130_fd_sc_hd__fill_2
XFILLER_31_97 VGND VGND VPWR VPWR sky130_fd_sc_hd__decap_3
Xoutput53 _1100_/Q VGND VGND VPWR VPWR o_receive_data[2] sky130_fd_sc_hd__clkdlybuf4s25_1
XFILLER_48_212 VGND VGND VPWR VPWR sky130_fd_sc_hd__decap_3
XFILLER_48_245 VGND VGND VPWR VPWR sky130_fd_sc_hd__decap_3
XFILLER_48_256 VGND VGND VPWR VPWR sky130_fd_sc_hd__decap_3
XFILLER_48_289 VGND VGND VPWR VPWR sky130_fd_sc_hd__decap_3
XFILLER_16_197 VGND VGND VPWR VPWR sky130_fd_sc_hd__decap_3
XFILLER_31_134 VGND VGND VPWR VPWR sky130_fd_sc_hd__decap_3
XFILLER_31_178 VGND VGND VPWR VPWR sky130_fd_sc_hd__decap_3
XFILLER_39_256 VGND VGND VPWR VPWR sky130_fd_sc_hd__decap_3
XFILLER_22_134 VGND VGND VPWR VPWR sky130_fd_sc_hd__decap_3
XFILLER_22_189 VGND VGND VPWR VPWR sky130_fd_sc_hd__decap_3
XFILLER_13_167 VGND VGND VPWR VPWR sky130_fd_sc_hd__fill_1
XFILLER_26_64 VGND VGND VPWR VPWR sky130_fd_sc_hd__fill_2
XFILLER_42_96 VGND VGND VPWR VPWR sky130_fd_sc_hd__decap_3
XFILLER_3_35 VGND VGND VPWR VPWR sky130_fd_sc_hd__fill_1
XFILLER_3_57 VGND VGND VPWR VPWR sky130_fd_sc_hd__fill_1
XFILLER_36_237 VGND VGND VPWR VPWR sky130_fd_sc_hd__decap_3
XFILLER_36_259 VGND VGND VPWR VPWR sky130_fd_sc_hd__decap_3
XFILLER_51_218 VGND VGND VPWR VPWR sky130_fd_sc_hd__decap_3
X_0984_ _1064_/A1 _1064_/A2 _1019_/B1 VGND VGND VPWR VPWR _0984_/X sky130_fd_sc_hd__o21a_2
Xfanout106 _1017_/B1 VGND VGND VPWR VPWR fanout106/X sky130_fd_sc_hd__clkdlybuf4s25_1
Xfanout128 input28/X VGND VGND VPWR VPWR _1061_/B1 sky130_fd_sc_hd__clkdlybuf4s25_1
XFILLER_27_237 VGND VGND VPWR VPWR sky130_fd_sc_hd__decap_3
XFILLER_35_281 VGND VGND VPWR VPWR sky130_fd_sc_hd__fill_1
XFILLER_50_251 VGND VGND VPWR VPWR sky130_fd_sc_hd__fill_1
XTAP_TAPCELL_ROW_37_298 VGND VPWR sky130_fd_sc_hd__tapvpwrvgnd_1
XFILLER_50_262 VGND VGND VPWR VPWR sky130_fd_sc_hd__decap_3
XFILLER_50_295 VGND VGND VPWR VPWR sky130_fd_sc_hd__decap_3
XFILLER_2_303 VGND VGND VPWR VPWR sky130_fd_sc_hd__fill_2
Xhold160 _1141_/Q VGND VGND VPWR VPWR hold160/X sky130_fd_sc_hd__dlygate4sd3_1
Xhold171 _1147_/Q VGND VGND VPWR VPWR hold171/X sky130_fd_sc_hd__dlygate4sd3_1
Xhold182 _1118_/Q VGND VGND VPWR VPWR hold182/X sky130_fd_sc_hd__dlygate4sd3_1
Xhold193 _1257_/Q VGND VGND VPWR VPWR hold193/X sky130_fd_sc_hd__dlygate4sd3_1
XFILLER_18_226 VGND VGND VPWR VPWR sky130_fd_sc_hd__decap_3
XFILLER_18_259 VGND VGND VPWR VPWR sky130_fd_sc_hd__decap_3
XFILLER_37_96 VGND VGND VPWR VPWR sky130_fd_sc_hd__decap_3
XFILLER_26_292 VGND VGND VPWR VPWR sky130_fd_sc_hd__decap_3
XTAP_TAPCELL_ROW_11_165 VGND VPWR sky130_fd_sc_hd__tapvpwrvgnd_1
X_1252_ clkload8/A _1252_/D _1060_/X VGND VGND VPWR VPWR _1252_/Q sky130_fd_sc_hd__dfstp_2
XFILLER_17_281 VGND VGND VPWR VPWR sky130_fd_sc_hd__decap_3
X_1183_ _1227_/CLK _1183_/D _1036_/B1 VGND VGND VPWR VPWR _1183_/Q sky130_fd_sc_hd__dfrtp_2
XFILLER_32_251 VGND VGND VPWR VPWR sky130_fd_sc_hd__fill_1
XFILLER_32_262 VGND VGND VPWR VPWR sky130_fd_sc_hd__decap_3
X_0967_ hold218/X _1170_/Q _0974_/S VGND VGND VPWR VPWR _0967_/X sky130_fd_sc_hd__mux2_1
XTAP_TAPCELL_ROW_34_279 VGND VPWR sky130_fd_sc_hd__tapvpwrvgnd_1
X_0898_ _1173_/D _0896_/Y _0897_/X _0617_/B VGND VGND VPWR VPWR _1108_/D sky130_fd_sc_hd__a22o_2
XPHY_EDGE_ROW_12_Right_12 VGND VGND VPWR VPWR sky130_fd_sc_hd__decap_3
XTAP_TAPCELL_ROW_2_122 VGND VPWR sky130_fd_sc_hd__tapvpwrvgnd_1
XPHY_EDGE_ROW_21_Right_21 VGND VGND VPWR VPWR sky130_fd_sc_hd__decap_3
XFILLER_23_240 VGND VGND VPWR VPWR sky130_fd_sc_hd__decap_3
XTAP_TAPCELL_ROW_25_235 VGND VPWR sky130_fd_sc_hd__tapvpwrvgnd_1
XPHY_EDGE_ROW_30_Right_30 VGND VGND VPWR VPWR sky130_fd_sc_hd__decap_3
XFILLER_2_144 VGND VGND VPWR VPWR sky130_fd_sc_hd__decap_3
XTAP_TAPCELL_ROW_48_349 VGND VPWR sky130_fd_sc_hd__tapvpwrvgnd_1
XFILLER_9_12 VGND VGND VPWR VPWR sky130_fd_sc_hd__decap_3
X_0821_ _1247_/Q _0821_/B VGND VGND VPWR VPWR _0822_/C sky130_fd_sc_hd__nand2_2
X_0752_ _0780_/A _0752_/B _0760_/A VGND VGND VPWR VPWR _1216_/D sky130_fd_sc_hd__and3b_2
X_0683_ _0551_/Y _1169_/Q _1197_/D VGND VGND VPWR VPWR _1169_/D sky130_fd_sc_hd__a21o_2
XFILLER_49_181 VGND VGND VPWR VPWR sky130_fd_sc_hd__decap_3
X_1235_ _1259_/CLK _1235_/D _1043_/X VGND VGND VPWR VPWR _1235_/Q sky130_fd_sc_hd__dfrtp_2
X_1166_ _1192_/CLK _1166_/D load_slew102/X VGND VGND VPWR VPWR _1166_/Q sky130_fd_sc_hd__dfrtp_2
XTAP_TAPCELL_ROW_39_305 VGND VPWR sky130_fd_sc_hd__tapvpwrvgnd_1
X_1097_ _1268_/CLK _1097_/D _1064_/B1 VGND VGND VPWR VPWR _1097_/Q sky130_fd_sc_hd__dfstp_2
XFILLER_20_298 VGND VGND VPWR VPWR sky130_fd_sc_hd__fill_2
XTAP_TAPCELL_ROW_30_260 VGND VPWR sky130_fd_sc_hd__tapvpwrvgnd_1
XFILLER_47_129 VGND VGND VPWR VPWR sky130_fd_sc_hd__decap_3
XFILLER_11_265 VGND VGND VPWR VPWR sky130_fd_sc_hd__decap_3
XFILLER_34_53 VGND VGND VPWR VPWR sky130_fd_sc_hd__fill_2
XFILLER_34_75 VGND VGND VPWR VPWR sky130_fd_sc_hd__fill_1
Xclkbuf_leaf_19_i_clk clkbuf_leaf_2_i_clk/A VGND VGND VPWR VPWR _1191_/CLK sky130_fd_sc_hd__clkbuf_8
XFILLER_50_74 VGND VGND VPWR VPWR sky130_fd_sc_hd__decap_3
Xload_slew117 fanout116/X VGND VGND VPWR VPWR load_slew117/X sky130_fd_sc_hd__clkbuf_2
XFILLER_38_107 VGND VGND VPWR VPWR sky130_fd_sc_hd__fill_2
X_1020_ _1038_/A1 _1038_/A2 _1020_/B1 VGND VGND VPWR VPWR _1020_/X sky130_fd_sc_hd__o21a_2
XFILLER_46_195 VGND VGND VPWR VPWR sky130_fd_sc_hd__fill_1
XTAP_TAPCELL_ROW_44_330 VGND VPWR sky130_fd_sc_hd__tapvpwrvgnd_1
X_0804_ _0804_/A _0804_/B _0804_/C VGND VGND VPWR VPWR _1241_/D sky130_fd_sc_hd__and3_2
X_0735_ _0735_/A _0735_/B VGND VGND VPWR VPWR _1232_/D sky130_fd_sc_hd__or2_2
X_0666_ _1161_/Q _1197_/Q _1080_/Q VGND VGND VPWR VPWR _0666_/X sky130_fd_sc_hd__and3_2
X_0597_ _1133_/Q _0578_/X _0600_/B VGND VGND VPWR VPWR _0598_/B sky130_fd_sc_hd__o21ai_2
XFILLER_37_184 VGND VGND VPWR VPWR sky130_fd_sc_hd__decap_3
X_1218_ _1226_/CLK _1218_/D _1026_/X VGND VGND VPWR VPWR _1218_/Q sky130_fd_sc_hd__dfrtp_2
X_1149_ _1236_/CLK _1149_/D _0997_/X VGND VGND VPWR VPWR _1149_/Q sky130_fd_sc_hd__dfrtp_2
XFILLER_20_11 VGND VGND VPWR VPWR sky130_fd_sc_hd__decap_3
XFILLER_16_302 VGND VGND VPWR VPWR sky130_fd_sc_hd__decap_3
XFILLER_43_165 VGND VGND VPWR VPWR sky130_fd_sc_hd__decap_3
XFILLER_43_198 VGND VGND VPWR VPWR sky130_fd_sc_hd__decap_3
XFILLER_45_52 VGND VGND VPWR VPWR sky130_fd_sc_hd__decap_3
XFILLER_34_132 VGND VGND VPWR VPWR sky130_fd_sc_hd__decap_3
X_1003_ _1063_/A1 _1063_/A2 _1019_/B1 VGND VGND VPWR VPWR _1003_/X sky130_fd_sc_hd__o21a_2
X_0718_ _0718_/A _0718_/B _0718_/C VGND VGND VPWR VPWR _1251_/D sky130_fd_sc_hd__nor3_2
XPHY_EDGE_ROW_6_Right_6 VGND VGND VPWR VPWR sky130_fd_sc_hd__decap_3
X_0649_ _0552_/Y _0648_/X _0645_/A hold278/X VGND VGND VPWR VPWR _1155_/D sky130_fd_sc_hd__a2bb2o_2
XFILLER_15_66 VGND VGND VPWR VPWR sky130_fd_sc_hd__fill_2
XFILLER_25_121 VGND VGND VPWR VPWR sky130_fd_sc_hd__decap_3
XFILLER_25_187 VGND VGND VPWR VPWR sky130_fd_sc_hd__fill_1
XFILLER_31_32 VGND VGND VPWR VPWR sky130_fd_sc_hd__fill_2
XFILLER_0_253 VGND VGND VPWR VPWR sky130_fd_sc_hd__fill_2
Xoutput54 _1101_/Q VGND VGND VPWR VPWR o_receive_data[3] sky130_fd_sc_hd__clkdlybuf4s25_1
XFILLER_0_297 VGND VGND VPWR VPWR sky130_fd_sc_hd__decap_3
XFILLER_48_224 VGND VGND VPWR VPWR sky130_fd_sc_hd__decap_3
XFILLER_48_268 VGND VGND VPWR VPWR sky130_fd_sc_hd__decap_3
XFILLER_39_213 VGND VGND VPWR VPWR sky130_fd_sc_hd__decap_3
XFILLER_39_268 VGND VGND VPWR VPWR sky130_fd_sc_hd__decap_3
XFILLER_47_290 VGND VGND VPWR VPWR sky130_fd_sc_hd__decap_3
XFILLER_26_32 VGND VGND VPWR VPWR sky130_fd_sc_hd__decap_3
XFILLER_45_249 VGND VGND VPWR VPWR sky130_fd_sc_hd__decap_3
XFILLER_42_42 VGND VGND VPWR VPWR sky130_fd_sc_hd__decap_3
XFILLER_42_64 VGND VGND VPWR VPWR sky130_fd_sc_hd__decap_3
XTAP_TAPCELL_ROW_8_150 VGND VPWR sky130_fd_sc_hd__tapvpwrvgnd_1
XFILLER_36_216 VGND VGND VPWR VPWR sky130_fd_sc_hd__decap_3
XFILLER_36_249 VGND VGND VPWR VPWR sky130_fd_sc_hd__decap_3
XFILLER_44_271 VGND VGND VPWR VPWR sky130_fd_sc_hd__fill_2
X_0983_ _1064_/A1 _1064_/A2 _1019_/B1 VGND VGND VPWR VPWR _0983_/X sky130_fd_sc_hd__o21a_2
Xfanout107 _1016_/B1 VGND VGND VPWR VPWR fanout107/X sky130_fd_sc_hd__clkdlybuf4s25_1
Xfanout118 fanout120/X VGND VGND VPWR VPWR _1042_/B1 sky130_fd_sc_hd__clkdlybuf4s25_1
XFILLER_8_183 VGND VGND VPWR VPWR sky130_fd_sc_hd__decap_3
XFILLER_10_105 VGND VGND VPWR VPWR sky130_fd_sc_hd__decap_3
XFILLER_35_260 VGND VGND VPWR VPWR sky130_fd_sc_hd__decap_3
XFILLER_42_208 VGND VGND VPWR VPWR sky130_fd_sc_hd__fill_2
XFILLER_50_230 VGND VGND VPWR VPWR sky130_fd_sc_hd__decap_3
XFILLER_50_274 VGND VGND VPWR VPWR sky130_fd_sc_hd__decap_3
Xhold150 _1079_/Q VGND VGND VPWR VPWR _0569_/A sky130_fd_sc_hd__dlygate4sd3_1
Xhold161 _0900_/X VGND VGND VPWR VPWR _1110_/D sky130_fd_sc_hd__dlygate4sd3_1
Xhold172 _1154_/Q VGND VGND VPWR VPWR hold172/X sky130_fd_sc_hd__dlygate4sd3_1
Xhold183 _1117_/Q VGND VGND VPWR VPWR hold183/X sky130_fd_sc_hd__dlygate4sd3_1
Xhold194 _1146_/Q VGND VGND VPWR VPWR _0735_/A sky130_fd_sc_hd__dlygate4sd3_1
XFILLER_18_205 VGND VGND VPWR VPWR sky130_fd_sc_hd__decap_3
XFILLER_18_238 VGND VGND VPWR VPWR sky130_fd_sc_hd__decap_3
XFILLER_26_260 VGND VGND VPWR VPWR sky130_fd_sc_hd__decap_3
XFILLER_5_120 VGND VGND VPWR VPWR sky130_fd_sc_hd__decap_3
XTAP_TAPCELL_ROW_11_166 VGND VPWR sky130_fd_sc_hd__tapvpwrvgnd_1
XFILLER_38_6 VGND VGND VPWR VPWR sky130_fd_sc_hd__fill_2
X_1251_ _1259_/CLK _1251_/D _1059_/X VGND VGND VPWR VPWR _1251_/Q sky130_fd_sc_hd__dfrtp_2
X_1182_ _1262_/CLK _1182_/D _1027_/B1 VGND VGND VPWR VPWR _1182_/Q sky130_fd_sc_hd__dfrtp_2
XFILLER_17_260 VGND VGND VPWR VPWR sky130_fd_sc_hd__decap_3
XFILLER_24_219 VGND VGND VPWR VPWR sky130_fd_sc_hd__decap_3
X_0966_ hold235/X _1265_/Q _1199_/Q VGND VGND VPWR VPWR _0966_/X sky130_fd_sc_hd__mux2_1
X_0897_ _1162_/Q _1119_/Q _1160_/Q VGND VGND VPWR VPWR _0897_/X sky130_fd_sc_hd__and3b_2
XTAP_TAPCELL_ROW_2_123 VGND VPWR sky130_fd_sc_hd__tapvpwrvgnd_1
XFILLER_23_252 VGND VGND VPWR VPWR sky130_fd_sc_hd__decap_3
XFILLER_23_55 VGND VGND VPWR VPWR sky130_fd_sc_hd__fill_1
XFILLER_23_88 VGND VGND VPWR VPWR sky130_fd_sc_hd__decap_3
XTAP_TAPCELL_ROW_25_236 VGND VPWR sky130_fd_sc_hd__tapvpwrvgnd_1
XFILLER_0_26 VGND VGND VPWR VPWR sky130_fd_sc_hd__fill_2
XFILLER_48_74 VGND VGND VPWR VPWR sky130_fd_sc_hd__fill_2
XFILLER_14_274 VGND VGND VPWR VPWR sky130_fd_sc_hd__decap_3
XFILLER_9_24 VGND VGND VPWR VPWR sky130_fd_sc_hd__decap_3
X_0820_ _1247_/Q _0821_/B VGND VGND VPWR VPWR _0822_/B sky130_fd_sc_hd__or2_2
X_0751_ _1214_/Q _1213_/Q _1215_/Q _1216_/Q VGND VGND VPWR VPWR _0752_/B sky130_fd_sc_hd__a31o_2
XFILLER_9_68 VGND VGND VPWR VPWR sky130_fd_sc_hd__decap_3
XFILLER_9_46 VGND VGND VPWR VPWR sky130_fd_sc_hd__fill_2
X_0682_ _0543_/Y _1170_/Q hold260/X hold223/X VGND VGND VPWR VPWR _0682_/X sky130_fd_sc_hd__a22o_2
XFILLER_49_160 VGND VGND VPWR VPWR sky130_fd_sc_hd__decap_3
XFILLER_49_193 VGND VGND VPWR VPWR sky130_fd_sc_hd__decap_3
X_1234_ _1236_/CLK _1234_/D _1042_/X VGND VGND VPWR VPWR _1234_/Q sky130_fd_sc_hd__dfrtp_2
X_1165_ _1226_/CLK _1165_/D fanout119/X VGND VGND VPWR VPWR _1165_/Q sky130_fd_sc_hd__dfrtp_2
X_1096_ _1227_/CLK _1096_/D fanout114/X VGND VGND VPWR VPWR _1096_/Q sky130_fd_sc_hd__dfrtp_2
XTAP_TAPCELL_ROW_39_306 VGND VPWR sky130_fd_sc_hd__tapvpwrvgnd_1
X_0949_ _1123_/Q _1124_/Q _1125_/Q _0949_/D VGND VGND VPWR VPWR _0955_/C sky130_fd_sc_hd__and4_2
XTAP_TAPCELL_ROW_30_261 VGND VPWR sky130_fd_sc_hd__tapvpwrvgnd_1
XFILLER_18_11 VGND VGND VPWR VPWR sky130_fd_sc_hd__fill_1
XFILLER_18_55 VGND VGND VPWR VPWR sky130_fd_sc_hd__decap_3
XFILLER_18_88 VGND VGND VPWR VPWR sky130_fd_sc_hd__fill_1
XFILLER_50_53 VGND VGND VPWR VPWR sky130_fd_sc_hd__decap_3
XFILLER_7_204 VGND VGND VPWR VPWR sky130_fd_sc_hd__fill_2
XFILLER_46_141 VGND VGND VPWR VPWR sky130_fd_sc_hd__fill_1
XFILLER_46_152 VGND VGND VPWR VPWR sky130_fd_sc_hd__decap_3
XTAP_TAPCELL_ROW_44_331 VGND VPWR sky130_fd_sc_hd__tapvpwrvgnd_1
XFILLER_6_281 VGND VGND VPWR VPWR sky130_fd_sc_hd__decap_3
X_0803_ _1241_/Q _0803_/B VGND VGND VPWR VPWR _0804_/C sky130_fd_sc_hd__or2_2
X_0734_ _0734_/A _1150_/Q VGND VGND VPWR VPWR _0734_/X sky130_fd_sc_hd__and2_2
X_0665_ _0543_/Y _1167_/Q hold214/X _1162_/Q VGND VGND VPWR VPWR _0665_/X sky130_fd_sc_hd__a22o_2
XFILLER_29_119 VGND VGND VPWR VPWR sky130_fd_sc_hd__fill_2
X_0596_ hold196/X _0598_/A _0595_/Y VGND VGND VPWR VPWR _1134_/D sky130_fd_sc_hd__a21oi_2
XFILLER_1_91 VGND VGND VPWR VPWR sky130_fd_sc_hd__decap_3
XFILLER_37_141 VGND VGND VPWR VPWR sky130_fd_sc_hd__fill_2
XFILLER_40_306 VGND VGND VPWR VPWR sky130_fd_sc_hd__fill_2
X_1217_ _1226_/CLK _1217_/D _1025_/X VGND VGND VPWR VPWR _1217_/Q sky130_fd_sc_hd__dfrtp_2
X_1148_ _1212_/CLK _1148_/D _0996_/X VGND VGND VPWR VPWR _1148_/Q sky130_fd_sc_hd__dfrtp_2
X_1079_ _1240_/CLK _1079_/D _1055_/B1 VGND VGND VPWR VPWR _1079_/Q sky130_fd_sc_hd__dfrtp_2
XFILLER_28_141 VGND VGND VPWR VPWR sky130_fd_sc_hd__fill_2
XFILLER_29_54 VGND VGND VPWR VPWR sky130_fd_sc_hd__fill_2
XFILLER_43_111 VGND VGND VPWR VPWR sky130_fd_sc_hd__fill_1
XFILLER_19_185 VGND VGND VPWR VPWR sky130_fd_sc_hd__decap_3
XFILLER_22_306 VGND VGND VPWR VPWR sky130_fd_sc_hd__fill_2
XFILLER_34_100 VGND VGND VPWR VPWR sky130_fd_sc_hd__decap_3
X_1002_ _1019_/A1 _1019_/A2 _1067_/B1 VGND VGND VPWR VPWR _1002_/X sky130_fd_sc_hd__o21a_2
X_0717_ _0717_/A _0717_/B VGND VGND VPWR VPWR _0718_/C sky130_fd_sc_hd__or2_2
X_0648_ _0648_/A _1211_/Q VGND VGND VPWR VPWR _0648_/X sky130_fd_sc_hd__or2_2
Xclkbuf_leaf_18_i_clk clkbuf_leaf_2_i_clk/A VGND VGND VPWR VPWR clkload4/A sky130_fd_sc_hd__clkbuf_8
X_0579_ _1140_/Q _1133_/Q _1132_/Q _1131_/Q VGND VGND VPWR VPWR _0598_/A sky130_fd_sc_hd__and4_2
XFILLER_13_306 VGND VGND VPWR VPWR sky130_fd_sc_hd__fill_2
XFILLER_15_45 VGND VGND VPWR VPWR sky130_fd_sc_hd__decap_3
XFILLER_31_55 VGND VGND VPWR VPWR sky130_fd_sc_hd__fill_1
XFILLER_40_169 VGND VGND VPWR VPWR sky130_fd_sc_hd__decap_3
XFILLER_0_221 VGND VGND VPWR VPWR sky130_fd_sc_hd__decap_3
XFILLER_0_276 VGND VGND VPWR VPWR sky130_fd_sc_hd__decap_3
XFILLER_48_203 VGND VGND VPWR VPWR sky130_fd_sc_hd__decap_3
Xoutput55 _1102_/Q VGND VGND VPWR VPWR o_receive_data[4] sky130_fd_sc_hd__clkdlybuf4s25_1
Xoutput44 _1283_/X VGND VGND VPWR VPWR o_cmd_status_reg[2] sky130_fd_sc_hd__clkdlybuf4s25_1
XFILLER_16_100 VGND VGND VPWR VPWR sky130_fd_sc_hd__decap_3
XFILLER_48_236 VGND VGND VPWR VPWR sky130_fd_sc_hd__decap_3
XFILLER_31_103 VGND VGND VPWR VPWR sky130_fd_sc_hd__fill_2
XFILLER_31_169 VGND VGND VPWR VPWR sky130_fd_sc_hd__decap_3
XFILLER_39_225 VGND VGND VPWR VPWR sky130_fd_sc_hd__fill_1
XTAP_TAPCELL_ROW_17_194 VGND VPWR sky130_fd_sc_hd__tapvpwrvgnd_1
XFILLER_7_90 VGND VGND VPWR VPWR sky130_fd_sc_hd__fill_1
XPHY_EDGE_ROW_37_Left_89 VGND VGND VPWR VPWR sky130_fd_sc_hd__decap_3
XFILLER_13_125 VGND VGND VPWR VPWR sky130_fd_sc_hd__decap_3
XFILLER_13_147 VGND VGND VPWR VPWR sky130_fd_sc_hd__fill_1
XFILLER_13_169 VGND VGND VPWR VPWR sky130_fd_sc_hd__decap_3
XFILLER_21_180 VGND VGND VPWR VPWR sky130_fd_sc_hd__fill_1
XFILLER_26_99 VGND VGND VPWR VPWR sky130_fd_sc_hd__decap_3
XFILLER_42_76 VGND VGND VPWR VPWR sky130_fd_sc_hd__fill_1
XTAP_TAPCELL_ROW_8_151 VGND VPWR sky130_fd_sc_hd__tapvpwrvgnd_1
XPHY_EDGE_ROW_48_Left_100 VGND VGND VPWR VPWR sky130_fd_sc_hd__decap_3
XFILLER_36_228 VGND VGND VPWR VPWR sky130_fd_sc_hd__fill_1
XFILLER_44_250 VGND VGND VPWR VPWR sky130_fd_sc_hd__fill_2
XFILLER_44_261 VGND VGND VPWR VPWR sky130_fd_sc_hd__decap_3
XFILLER_51_209 VGND VGND VPWR VPWR sky130_fd_sc_hd__decap_3
X_0982_ _1019_/A1 _1019_/A2 _1019_/B1 VGND VGND VPWR VPWR _0982_/X sky130_fd_sc_hd__o21a_2
XFILLER_8_162 VGND VGND VPWR VPWR sky130_fd_sc_hd__decap_3
Xfanout119 fanout120/X VGND VGND VPWR VPWR fanout119/X sky130_fd_sc_hd__clkdlybuf4s25_1
XFILLER_27_228 VGND VGND VPWR VPWR sky130_fd_sc_hd__fill_1
XFILLER_10_117 VGND VGND VPWR VPWR sky130_fd_sc_hd__fill_1
XFILLER_50_242 VGND VGND VPWR VPWR sky130_fd_sc_hd__decap_3
XFILLER_50_253 VGND VGND VPWR VPWR sky130_fd_sc_hd__decap_3
XFILLER_50_286 VGND VGND VPWR VPWR sky130_fd_sc_hd__decap_3
Xhold140 _1187_/Q VGND VGND VPWR VPWR _1181_/D sky130_fd_sc_hd__dlygate4sd3_1
Xhold151 _1148_/Q VGND VGND VPWR VPWR _0839_/C sky130_fd_sc_hd__dlygate4sd3_1
Xhold162 _1102_/Q VGND VGND VPWR VPWR hold162/X sky130_fd_sc_hd__dlygate4sd3_1
Xhold173 _0651_/X VGND VGND VPWR VPWR _1153_/D sky130_fd_sc_hd__dlygate4sd3_1
Xhold184 _1116_/Q VGND VGND VPWR VPWR hold184/X sky130_fd_sc_hd__dlygate4sd3_1
Xhold195 _0642_/X VGND VGND VPWR VPWR _1150_/D sky130_fd_sc_hd__dlygate4sd3_1
XFILLER_18_217 VGND VGND VPWR VPWR sky130_fd_sc_hd__decap_3
XFILLER_26_272 VGND VGND VPWR VPWR sky130_fd_sc_hd__decap_3
XFILLER_41_231 VGND VGND VPWR VPWR sky130_fd_sc_hd__decap_3
XTAP_TAPCELL_ROW_11_167 VGND VPWR sky130_fd_sc_hd__tapvpwrvgnd_1
X_1250_ _1259_/CLK _1250_/D _1058_/X VGND VGND VPWR VPWR _1250_/Q sky130_fd_sc_hd__dfrtp_2
X_1181_ _1227_/CLK _1181_/D _1036_/B1 VGND VGND VPWR VPWR _1181_/Q sky130_fd_sc_hd__dfrtp_2
XFILLER_32_253 VGND VGND VPWR VPWR sky130_fd_sc_hd__decap_3
X_0965_ hold240/X _1264_/Q _1199_/Q VGND VGND VPWR VPWR _0965_/X sky130_fd_sc_hd__mux2_1
X_0896_ _1119_/Q _1160_/Q _1162_/Q VGND VGND VPWR VPWR _0896_/Y sky130_fd_sc_hd__a21oi_2
XFILLER_23_220 VGND VGND VPWR VPWR sky130_fd_sc_hd__decap_3
XFILLER_23_231 VGND VGND VPWR VPWR sky130_fd_sc_hd__decap_3
XTAP_TAPCELL_ROW_25_237 VGND VPWR sky130_fd_sc_hd__tapvpwrvgnd_1
XFILLER_2_157 VGND VGND VPWR VPWR sky130_fd_sc_hd__decap_3
XFILLER_14_231 VGND VGND VPWR VPWR sky130_fd_sc_hd__decap_3
XFILLER_14_253 VGND VGND VPWR VPWR sky130_fd_sc_hd__fill_1
Xfanout90 _1199_/Q VGND VGND VPWR VPWR _0970_/S sky130_fd_sc_hd__clkdlybuf4s25_1
X_0750_ _1214_/Q _1213_/Q _1215_/Q _1216_/Q VGND VGND VPWR VPWR _0780_/A sky130_fd_sc_hd__and4_2
X_0681_ hold222/X hold197/X hold288/X _0555_/Y VGND VGND VPWR VPWR _1159_/D sky130_fd_sc_hd__a22o_2
XPHY_EDGE_ROW_24_Left_76 VGND VGND VPWR VPWR sky130_fd_sc_hd__decap_3
XFILLER_29_3 VGND VGND VPWR VPWR sky130_fd_sc_hd__decap_3
X_1233_ _1233_/CLK _1233_/D _1041_/X VGND VGND VPWR VPWR _1233_/Q sky130_fd_sc_hd__dfrtp_2
XTAP_TAPCELL_ROW_39_307 VGND VPWR sky130_fd_sc_hd__tapvpwrvgnd_1
XFILLER_49_172 VGND VGND VPWR VPWR sky130_fd_sc_hd__decap_3
X_1164_ _1233_/CLK _1164_/D _1042_/B1 VGND VGND VPWR VPWR _1164_/Q sky130_fd_sc_hd__dfrtp_2
X_1095_ _1227_/CLK _1095_/D fanout114/X VGND VGND VPWR VPWR _1095_/Q sky130_fd_sc_hd__dfrtp_2
XFILLER_20_223 VGND VGND VPWR VPWR sky130_fd_sc_hd__fill_1
XFILLER_20_267 VGND VGND VPWR VPWR sky130_fd_sc_hd__decap_3
XFILLER_20_289 VGND VGND VPWR VPWR sky130_fd_sc_hd__decap_3
X_0948_ _1125_/Q _0948_/B VGND VGND VPWR VPWR _0950_/C sky130_fd_sc_hd__or2_2
XTAP_TAPCELL_ROW_30_262 VGND VPWR sky130_fd_sc_hd__tapvpwrvgnd_1
X_0879_ _0891_/A _1269_/Q VGND VGND VPWR VPWR _0880_/S sky130_fd_sc_hd__nand2_2
XFILLER_11_223 VGND VGND VPWR VPWR sky130_fd_sc_hd__fill_1
XFILLER_43_304 VGND VGND VPWR VPWR sky130_fd_sc_hd__decap_3
XFILLER_50_65 VGND VGND VPWR VPWR sky130_fd_sc_hd__decap_3
Xload_slew108 fanout107/X VGND VGND VPWR VPWR load_slew108/X sky130_fd_sc_hd__clkbuf_4
XFILLER_15_9 VGND VGND VPWR VPWR sky130_fd_sc_hd__fill_1
XFILLER_46_197 VGND VGND VPWR VPWR sky130_fd_sc_hd__decap_3
Xload_slew99 fanout98/X VGND VGND VPWR VPWR load_slew99/X sky130_fd_sc_hd__clkbuf_4
X_0802_ _1241_/Q _0803_/B VGND VGND VPWR VPWR _0804_/B sky130_fd_sc_hd__nand2_2
XTAP_TAPCELL_ROW_44_332 VGND VPWR sky130_fd_sc_hd__tapvpwrvgnd_1
X_0733_ _1160_/Q _0733_/B VGND VGND VPWR VPWR _1187_/D sky130_fd_sc_hd__and2_2
X_0664_ _0658_/A _0553_/Y _1193_/D VGND VGND VPWR VPWR _1168_/D sky130_fd_sc_hd__a21o_2
X_1216_ _1226_/CLK _1216_/D _1024_/X VGND VGND VPWR VPWR _1216_/Q sky130_fd_sc_hd__dfrtp_2
X_0595_ _1134_/Q _0598_/A _0600_/B VGND VGND VPWR VPWR _0595_/Y sky130_fd_sc_hd__o21ai_2
XFILLER_25_304 VGND VGND VPWR VPWR sky130_fd_sc_hd__decap_3
XFILLER_37_175 VGND VGND VPWR VPWR sky130_fd_sc_hd__decap_3
X_1147_ _1236_/CLK _1147_/D _0995_/X VGND VGND VPWR VPWR _1147_/Q sky130_fd_sc_hd__dfrtp_2
X_1078_ _1240_/CLK _1078_/D _1055_/B1 VGND VGND VPWR VPWR _1078_/Q sky130_fd_sc_hd__dfrtp_2
XFILLER_29_22 VGND VGND VPWR VPWR sky130_fd_sc_hd__fill_2
XFILLER_43_123 VGND VGND VPWR VPWR sky130_fd_sc_hd__decap_3
XFILLER_45_43 VGND VGND VPWR VPWR sky130_fd_sc_hd__decap_3
XFILLER_31_307 VGND VGND VPWR VPWR sky130_fd_sc_hd__fill_1
XFILLER_43_178 VGND VGND VPWR VPWR sky130_fd_sc_hd__decap_3
XFILLER_13_6 VGND VGND VPWR VPWR sky130_fd_sc_hd__fill_1
XFILLER_19_164 VGND VGND VPWR VPWR sky130_fd_sc_hd__decap_3
X_1001_ _1061_/A1 _1061_/A2 _1067_/B1 VGND VGND VPWR VPWR _1001_/X sky130_fd_sc_hd__o21a_2
X_0716_ _1244_/Q _1243_/Q _1246_/Q _1245_/Q VGND VGND VPWR VPWR _0717_/B sky130_fd_sc_hd__or4_2
X_0647_ _1145_/Q _0550_/Y _0839_/C hold223/X VGND VGND VPWR VPWR _0647_/X sky130_fd_sc_hd__a22o_2
X_0578_ _1140_/Q _1132_/Q _1131_/Q VGND VGND VPWR VPWR _0578_/X sky130_fd_sc_hd__and3_2
XPHY_EDGE_ROW_11_Left_63 VGND VGND VPWR VPWR sky130_fd_sc_hd__decap_3
XFILLER_15_57 VGND VGND VPWR VPWR sky130_fd_sc_hd__decap_3
XFILLER_25_167 VGND VGND VPWR VPWR sky130_fd_sc_hd__fill_1
XFILLER_25_178 VGND VGND VPWR VPWR sky130_fd_sc_hd__decap_3
XFILLER_48_215 VGND VGND VPWR VPWR sky130_fd_sc_hd__decap_3
XFILLER_48_248 VGND VGND VPWR VPWR sky130_fd_sc_hd__decap_3
XFILLER_48_259 VGND VGND VPWR VPWR sky130_fd_sc_hd__decap_3
Xoutput56 _1103_/Q VGND VGND VPWR VPWR o_receive_data[5] sky130_fd_sc_hd__clkdlybuf4s25_1
Xoutput45 _1284_/X VGND VGND VPWR VPWR o_cmd_status_reg[3] sky130_fd_sc_hd__clkdlybuf4s25_1
XFILLER_31_137 VGND VGND VPWR VPWR sky130_fd_sc_hd__fill_2
XFILLER_39_259 VGND VGND VPWR VPWR sky130_fd_sc_hd__decap_3
XFILLER_47_281 VGND VGND VPWR VPWR sky130_fd_sc_hd__decap_3
XFILLER_22_137 VGND VGND VPWR VPWR sky130_fd_sc_hd__decap_3
XTAP_TAPCELL_ROW_17_195 VGND VPWR sky130_fd_sc_hd__tapvpwrvgnd_1
XFILLER_42_99 VGND VGND VPWR VPWR sky130_fd_sc_hd__decap_3
XTAP_TAPCELL_ROW_8_152 VGND VPWR sky130_fd_sc_hd__tapvpwrvgnd_1
XFILLER_29_281 VGND VGND VPWR VPWR sky130_fd_sc_hd__fill_1
X_0981_ _1064_/A1 _1064_/A2 _1019_/B1 VGND VGND VPWR VPWR _0981_/X sky130_fd_sc_hd__o21a_2
Xclkbuf_leaf_17_i_clk clkload0/A VGND VGND VPWR VPWR _1233_/CLK sky130_fd_sc_hd__clkbuf_8
Xfanout109 _1017_/B1 VGND VGND VPWR VPWR _1016_/B1 sky130_fd_sc_hd__clkdlybuf4s25_1
XFILLER_50_221 VGND VGND VPWR VPWR sky130_fd_sc_hd__decap_3
XFILLER_50_265 VGND VGND VPWR VPWR sky130_fd_sc_hd__decap_3
XFILLER_50_298 VGND VGND VPWR VPWR sky130_fd_sc_hd__decap_3
XFILLER_12_69 VGND VGND VPWR VPWR sky130_fd_sc_hd__decap_3
Xhold141 _1193_/Q VGND VGND VPWR VPWR _1195_/D sky130_fd_sc_hd__dlygate4sd3_1
Xhold152 _0839_/Y VGND VGND VPWR VPWR _1230_/D sky130_fd_sc_hd__dlygate4sd3_1
Xhold163 _1104_/Q VGND VGND VPWR VPWR hold163/X sky130_fd_sc_hd__dlygate4sd3_1
Xhold174 _1151_/Q VGND VGND VPWR VPWR _0614_/A sky130_fd_sc_hd__dlygate4sd3_1
Xhold185 _1130_/Q VGND VGND VPWR VPWR _0612_/A sky130_fd_sc_hd__dlygate4sd3_1
XFILLER_18_229 VGND VGND VPWR VPWR sky130_fd_sc_hd__decap_3
Xhold196 _1134_/Q VGND VGND VPWR VPWR hold196/X sky130_fd_sc_hd__dlygate4sd3_1
XFILLER_26_295 VGND VGND VPWR VPWR sky130_fd_sc_hd__decap_3
XFILLER_37_99 VGND VGND VPWR VPWR sky130_fd_sc_hd__decap_3
XFILLER_41_210 VGND VGND VPWR VPWR sky130_fd_sc_hd__decap_3
XTAP_TAPCELL_ROW_36_290 VGND VPWR sky130_fd_sc_hd__tapvpwrvgnd_1
XFILLER_41_276 VGND VGND VPWR VPWR sky130_fd_sc_hd__decap_3
XFILLER_5_100 VGND VGND VPWR VPWR sky130_fd_sc_hd__decap_3
XFILLER_5_111 VGND VGND VPWR VPWR sky130_fd_sc_hd__fill_1
XTAP_TAPCELL_ROW_11_168 VGND VPWR sky130_fd_sc_hd__tapvpwrvgnd_1
XFILLER_17_240 VGND VGND VPWR VPWR sky130_fd_sc_hd__decap_3
XFILLER_17_251 VGND VGND VPWR VPWR sky130_fd_sc_hd__decap_3
X_1180_ _1192_/CLK _1180_/D load_slew117/X VGND VGND VPWR VPWR _1180_/Q sky130_fd_sc_hd__dfrtp_2
XFILLER_17_284 VGND VGND VPWR VPWR sky130_fd_sc_hd__decap_3
X_0964_ hold228/X _1263_/Q _0970_/S VGND VGND VPWR VPWR _0964_/X sky130_fd_sc_hd__mux2_1
X_0895_ _0895_/A _0895_/B VGND VGND VPWR VPWR _1107_/D sky130_fd_sc_hd__nor2_2
XFILLER_4_81 VGND VGND VPWR VPWR sky130_fd_sc_hd__decap_3
XFILLER_23_243 VGND VGND VPWR VPWR sky130_fd_sc_hd__fill_2
XFILLER_23_265 VGND VGND VPWR VPWR sky130_fd_sc_hd__decap_3
XTAP_TAPCELL_ROW_25_238 VGND VPWR sky130_fd_sc_hd__tapvpwrvgnd_1
XFILLER_23_276 VGND VGND VPWR VPWR sky130_fd_sc_hd__fill_1
XFILLER_23_46 VGND VGND VPWR VPWR sky130_fd_sc_hd__decap_3
XFILLER_23_57 VGND VGND VPWR VPWR sky130_fd_sc_hd__decap_3
XFILLER_2_147 VGND VGND VPWR VPWR sky130_fd_sc_hd__fill_1
XFILLER_46_302 VGND VGND VPWR VPWR sky130_fd_sc_hd__decap_3
XFILLER_14_265 VGND VGND VPWR VPWR sky130_fd_sc_hd__decap_3
Xfanout80 fanout86/X VGND VGND VPWR VPWR _1036_/A2 sky130_fd_sc_hd__clkdlybuf4s25_1
Xfanout91 _0861_/S VGND VGND VPWR VPWR _0860_/S sky130_fd_sc_hd__clkdlybuf4s25_1
XFILLER_9_15 VGND VGND VPWR VPWR sky130_fd_sc_hd__decap_3
X_0680_ _0680_/A _0680_/B VGND VGND VPWR VPWR _1160_/D sky130_fd_sc_hd__nor2_2
XFILLER_37_302 VGND VGND VPWR VPWR sky130_fd_sc_hd__decap_3
XFILLER_49_151 VGND VGND VPWR VPWR sky130_fd_sc_hd__decap_3
XFILLER_49_184 VGND VGND VPWR VPWR sky130_fd_sc_hd__decap_3
X_1232_ _1236_/CLK _1232_/D _1040_/X VGND VGND VPWR VPWR _1232_/Q sky130_fd_sc_hd__dfrtp_2
XTAP_TAPCELL_ROW_39_308 VGND VPWR sky130_fd_sc_hd__tapvpwrvgnd_1
X_1163_ _1191_/CLK _1163_/D load_slew102/X VGND VGND VPWR VPWR _1163_/Q sky130_fd_sc_hd__dfrtp_2
X_1094_ _1227_/CLK _1094_/D load_slew115/X VGND VGND VPWR VPWR _1287_/A sky130_fd_sc_hd__dfrtp_2
X_0947_ _0948_/B _0956_/A _0947_/C VGND VGND VPWR VPWR _1124_/D sky130_fd_sc_hd__and3b_2
XTAP_TAPCELL_ROW_30_263 VGND VPWR sky130_fd_sc_hd__tapvpwrvgnd_1
XTAP_TAPCELL_ROW_22_219 VGND VPWR sky130_fd_sc_hd__tapvpwrvgnd_1
X_0878_ _0575_/A hold167/X _0878_/S VGND VGND VPWR VPWR _1098_/D sky130_fd_sc_hd__mux2_1
XPHY_EDGE_ROW_41_Left_93 VGND VGND VPWR VPWR sky130_fd_sc_hd__decap_3
XFILLER_11_268 VGND VGND VPWR VPWR sky130_fd_sc_hd__decap_3
XFILLER_50_77 VGND VGND VPWR VPWR sky130_fd_sc_hd__decap_3
Xclkload0 clkload0/A VGND VGND VPWR VPWR clkload0/X sky130_fd_sc_hd__clkbuf_8
XFILLER_19_302 VGND VGND VPWR VPWR sky130_fd_sc_hd__decap_3
XFILLER_46_110 VGND VGND VPWR VPWR sky130_fd_sc_hd__fill_2
XTAP_TAPCELL_ROW_44_333 VGND VPWR sky130_fd_sc_hd__tapvpwrvgnd_1
X_0801_ _0565_/Y _0799_/B _0803_/B _0815_/A VGND VGND VPWR VPWR _1240_/D sky130_fd_sc_hd__a211oi_2
X_0732_ _1159_/Q hold284/X _0674_/X VGND VGND VPWR VPWR _1190_/D sky130_fd_sc_hd__a21o_2
X_0663_ _1191_/D _0662_/X _0680_/A VGND VGND VPWR VPWR _1193_/D sky130_fd_sc_hd__o21a_2
X_0594_ _0580_/X _0600_/B _0594_/C VGND VGND VPWR VPWR _1135_/D sky130_fd_sc_hd__and3b_2
X_1215_ _1240_/CLK _1215_/D _1023_/X VGND VGND VPWR VPWR _1215_/Q sky130_fd_sc_hd__dfrtp_2
X_1146_ _1236_/CLK _1146_/D _0994_/X VGND VGND VPWR VPWR _1146_/Q sky130_fd_sc_hd__dfrtp_2
XFILLER_37_187 VGND VGND VPWR VPWR sky130_fd_sc_hd__fill_2
X_1077_ _1262_/CLK _1077_/D hold133/X VGND VGND VPWR VPWR _1077_/Q sky130_fd_sc_hd__dfrtp_2
XFILLER_20_14 VGND VGND VPWR VPWR sky130_fd_sc_hd__fill_1
XFILLER_20_36 VGND VGND VPWR VPWR sky130_fd_sc_hd__fill_2
XFILLER_16_305 VGND VGND VPWR VPWR sky130_fd_sc_hd__decap_3
XFILLER_28_110 VGND VGND VPWR VPWR sky130_fd_sc_hd__fill_1
XFILLER_43_102 VGND VGND VPWR VPWR sky130_fd_sc_hd__decap_3
XFILLER_43_157 VGND VGND VPWR VPWR sky130_fd_sc_hd__fill_1
XFILLER_45_55 VGND VGND VPWR VPWR sky130_fd_sc_hd__fill_1
XFILLER_45_77 VGND VGND VPWR VPWR sky130_fd_sc_hd__decap_3
XFILLER_51_190 VGND VGND VPWR VPWR sky130_fd_sc_hd__decap_3
XTAP_TAPCELL_ROW_41_314 VGND VPWR sky130_fd_sc_hd__tapvpwrvgnd_1
XFILLER_3_242 VGND VGND VPWR VPWR sky130_fd_sc_hd__decap_3
X_1000_ _1063_/A1 _1063_/A2 _1060_/B1 VGND VGND VPWR VPWR _1000_/X sky130_fd_sc_hd__o21a_2
X_0715_ _1248_/Q _1247_/Q _1250_/Q _1249_/Q VGND VGND VPWR VPWR _0717_/A sky130_fd_sc_hd__or4_2
X_0646_ hold171/X _0549_/Y _0735_/B VGND VGND VPWR VPWR _1147_/D sky130_fd_sc_hd__a21o_2
X_0577_ _1140_/Q _0546_/Y _0548_/Y hold220/X VGND VGND VPWR VPWR _1140_/D sky130_fd_sc_hd__a31o_2
XFILLER_25_124 VGND VGND VPWR VPWR sky130_fd_sc_hd__decap_3
XFILLER_25_157 VGND VGND VPWR VPWR sky130_fd_sc_hd__fill_2
X_1129_ _1259_/CLK _1129_/D _0977_/X VGND VGND VPWR VPWR _1129_/Q sky130_fd_sc_hd__dfrtp_2
XFILLER_31_57 VGND VGND VPWR VPWR sky130_fd_sc_hd__decap_3
Xoutput57 _1104_/Q VGND VGND VPWR VPWR o_receive_data[6] sky130_fd_sc_hd__clkdlybuf4s25_1
Xoutput46 _1285_/X VGND VGND VPWR VPWR o_cmd_status_reg[4] sky130_fd_sc_hd__clkdlybuf4s25_1
XFILLER_48_227 VGND VGND VPWR VPWR sky130_fd_sc_hd__decap_3
XPHY_EDGE_ROW_19_Right_19 VGND VGND VPWR VPWR sky130_fd_sc_hd__decap_3
XFILLER_39_216 VGND VGND VPWR VPWR sky130_fd_sc_hd__decap_3
XPHY_EDGE_ROW_28_Right_28 VGND VGND VPWR VPWR sky130_fd_sc_hd__decap_3
XFILLER_47_293 VGND VGND VPWR VPWR sky130_fd_sc_hd__decap_3
XPHY_EDGE_ROW_37_Right_37 VGND VGND VPWR VPWR sky130_fd_sc_hd__decap_3
XFILLER_30_160 VGND VGND VPWR VPWR sky130_fd_sc_hd__decap_3
XTAP_TAPCELL_ROW_17_196 VGND VPWR sky130_fd_sc_hd__tapvpwrvgnd_1
XPHY_EDGE_ROW_46_Right_46 VGND VGND VPWR VPWR sky130_fd_sc_hd__decap_3
X_0629_ _0628_/A _0628_/C _0628_/B VGND VGND VPWR VPWR _0630_/B sky130_fd_sc_hd__o21ai_2
XFILLER_42_45 VGND VGND VPWR VPWR sky130_fd_sc_hd__decap_3
XFILLER_42_67 VGND VGND VPWR VPWR sky130_fd_sc_hd__decap_3
XTAP_TAPCELL_ROW_8_153 VGND VPWR sky130_fd_sc_hd__tapvpwrvgnd_1
XFILLER_36_219 VGND VGND VPWR VPWR sky130_fd_sc_hd__decap_3
Xclkbuf_0_i_clk i_clk VGND VGND VPWR VPWR clkbuf_0_i_clk/X sky130_fd_sc_hd__clkbuf_16
X_0980_ _1017_/A1 _1017_/A2 _1019_/B1 VGND VGND VPWR VPWR _0980_/X sky130_fd_sc_hd__o21a_2
XFILLER_8_197 VGND VGND VPWR VPWR sky130_fd_sc_hd__fill_2
XFILLER_8_186 VGND VGND VPWR VPWR sky130_fd_sc_hd__fill_2
XFILLER_35_230 VGND VGND VPWR VPWR sky130_fd_sc_hd__decap_3
XFILLER_35_241 VGND VGND VPWR VPWR sky130_fd_sc_hd__decap_3
XFILLER_35_263 VGND VGND VPWR VPWR sky130_fd_sc_hd__fill_1
XFILLER_50_200 VGND VGND VPWR VPWR sky130_fd_sc_hd__decap_3
XFILLER_50_233 VGND VGND VPWR VPWR sky130_fd_sc_hd__decap_3
XFILLER_10_108 VGND VGND VPWR VPWR sky130_fd_sc_hd__decap_3
XFILLER_50_277 VGND VGND VPWR VPWR sky130_fd_sc_hd__decap_3
Xhold142 _1109_/Q VGND VGND VPWR VPWR _1175_/D sky130_fd_sc_hd__dlygate4sd3_1
Xhold153 _1143_/Q VGND VGND VPWR VPWR _0731_/A sky130_fd_sc_hd__dlygate4sd3_1
Xhold164 _1101_/Q VGND VGND VPWR VPWR hold164/X sky130_fd_sc_hd__dlygate4sd3_1
Xhold175 _0641_/X VGND VGND VPWR VPWR _1151_/D sky130_fd_sc_hd__dlygate4sd3_1
Xhold186 _1254_/Q VGND VGND VPWR VPWR hold186/X sky130_fd_sc_hd__dlygate4sd3_1
Xhold197 _1165_/Q VGND VGND VPWR VPWR hold197/X sky130_fd_sc_hd__dlygate4sd3_1
XFILLER_18_208 VGND VGND VPWR VPWR sky130_fd_sc_hd__decap_3
XFILLER_26_230 VGND VGND VPWR VPWR sky130_fd_sc_hd__fill_1
XFILLER_37_67 VGND VGND VPWR VPWR sky130_fd_sc_hd__decap_3
XTAP_TAPCELL_ROW_5_134 VGND VPWR sky130_fd_sc_hd__tapvpwrvgnd_1
XFILLER_26_263 VGND VGND VPWR VPWR sky130_fd_sc_hd__decap_3
XFILLER_41_222 VGND VGND VPWR VPWR sky130_fd_sc_hd__fill_2
XFILLER_41_255 VGND VGND VPWR VPWR sky130_fd_sc_hd__decap_3
XTAP_TAPCELL_ROW_36_291 VGND VPWR sky130_fd_sc_hd__tapvpwrvgnd_1
XFILLER_5_123 VGND VGND VPWR VPWR sky130_fd_sc_hd__fill_2
XFILLER_5_167 VGND VGND VPWR VPWR sky130_fd_sc_hd__fill_1
XFILLER_17_263 VGND VGND VPWR VPWR sky130_fd_sc_hd__decap_3
XFILLER_32_222 VGND VGND VPWR VPWR sky130_fd_sc_hd__fill_2
X_0963_ hold243/X hold240/X _0970_/S VGND VGND VPWR VPWR _1267_/D sky130_fd_sc_hd__mux2_1
X_0894_ _1288_/A _1162_/Q _1165_/Q _1234_/Q VGND VGND VPWR VPWR _0895_/B sky130_fd_sc_hd__a2bb2o_2
XFILLER_23_211 VGND VGND VPWR VPWR sky130_fd_sc_hd__decap_3
XFILLER_23_255 VGND VGND VPWR VPWR sky130_fd_sc_hd__fill_2
XFILLER_3_6 VGND VGND VPWR VPWR sky130_fd_sc_hd__decap_3
XFILLER_48_11 VGND VGND VPWR VPWR sky130_fd_sc_hd__decap_3
XFILLER_0_29 VGND VGND VPWR VPWR sky130_fd_sc_hd__decap_3
XFILLER_14_222 VGND VGND VPWR VPWR sky130_fd_sc_hd__decap_3
Xclkbuf_leaf_16_i_clk clkload0/A VGND VGND VPWR VPWR _1192_/CLK sky130_fd_sc_hd__clkbuf_8
Xfanout70 _1067_/A1 VGND VGND VPWR VPWR _1061_/A1 sky130_fd_sc_hd__clkdlybuf4s25_1
Xfanout81 fanout86/X VGND VGND VPWR VPWR _1027_/A2 sky130_fd_sc_hd__clkdlybuf4s25_1
Xfanout92 _0874_/S VGND VGND VPWR VPWR _0861_/S sky130_fd_sc_hd__clkdlybuf4s25_1
XFILLER_9_27 VGND VGND VPWR VPWR sky130_fd_sc_hd__fill_2
XFILLER_49_163 VGND VGND VPWR VPWR sky130_fd_sc_hd__decap_3
XFILLER_49_196 VGND VGND VPWR VPWR sky130_fd_sc_hd__decap_3
X_1231_ clkload4/A _1231_/D _1039_/X VGND VGND VPWR VPWR _1231_/Q sky130_fd_sc_hd__dfrtp_2
X_1162_ _1233_/CLK _1162_/D fanout119/X VGND VGND VPWR VPWR _1162_/Q sky130_fd_sc_hd__dfrtp_2
X_1093_ _1227_/CLK _1093_/D load_slew115/X VGND VGND VPWR VPWR _1286_/A sky130_fd_sc_hd__dfrtp_2
X_0946_ _1123_/Q _1124_/Q _0949_/D VGND VGND VPWR VPWR _0948_/B sky130_fd_sc_hd__and3_2
X_0877_ _0891_/A _1267_/Q VGND VGND VPWR VPWR _0878_/S sky130_fd_sc_hd__nand2_2
XFILLER_9_281 VGND VGND VPWR VPWR sky130_fd_sc_hd__fill_1
XFILLER_28_303 VGND VGND VPWR VPWR sky130_fd_sc_hd__decap_3
XFILLER_11_225 VGND VGND VPWR VPWR sky130_fd_sc_hd__decap_3
XFILLER_34_24 VGND VGND VPWR VPWR sky130_fd_sc_hd__decap_3
XFILLER_50_23 VGND VGND VPWR VPWR sky130_fd_sc_hd__decap_3
Xclkload1 clkload1/A VGND VGND VPWR VPWR clkload1/X sky130_fd_sc_hd__clkbuf_8
XFILLER_1_3 VGND VGND VPWR VPWR sky130_fd_sc_hd__decap_3
XFILLER_50_56 VGND VGND VPWR VPWR sky130_fd_sc_hd__decap_3
XFILLER_46_155 VGND VGND VPWR VPWR sky130_fd_sc_hd__decap_3
XFILLER_6_251 VGND VGND VPWR VPWR sky130_fd_sc_hd__fill_1
X_0800_ _1239_/Q _1240_/Q _0824_/A VGND VGND VPWR VPWR _0803_/B sky130_fd_sc_hd__and3_2
X_0731_ _0731_/A _1144_/Q VGND VGND VPWR VPWR _0731_/Y sky130_fd_sc_hd__nor2_2
XFILLER_34_3 VGND VGND VPWR VPWR sky130_fd_sc_hd__decap_3
XFILLER_6_284 VGND VGND VPWR VPWR sky130_fd_sc_hd__decap_3
X_0662_ _1081_/Q _1197_/Q _0678_/B _0662_/D VGND VGND VPWR VPWR _0662_/X sky130_fd_sc_hd__and4_2
X_0593_ _1134_/Q _0598_/A _1135_/Q VGND VGND VPWR VPWR _0594_/C sky130_fd_sc_hd__a21o_2
XFILLER_37_166 VGND VGND VPWR VPWR sky130_fd_sc_hd__fill_2
X_1214_ _1240_/CLK _1214_/D _1022_/X VGND VGND VPWR VPWR _1214_/Q sky130_fd_sc_hd__dfrtp_2
X_1145_ clkload8/A _1145_/D _0993_/X VGND VGND VPWR VPWR _1145_/Q sky130_fd_sc_hd__dfstp_2
X_1076_ _1191_/CLK _1076_/D load_slew102/X VGND VGND VPWR VPWR _1076_/Q sky130_fd_sc_hd__dfrtp_2
XTAP_TAPCELL_ROW_50_359 VGND VPWR sky130_fd_sc_hd__tapvpwrvgnd_1
X_0929_ _0927_/X _0928_/X _1119_/Q VGND VGND VPWR VPWR _0930_/B sky130_fd_sc_hd__a21oi_2
XFILLER_29_57 VGND VGND VPWR VPWR sky130_fd_sc_hd__fill_2
XFILLER_43_169 VGND VGND VPWR VPWR sky130_fd_sc_hd__decap_3
XTAP_TAPCELL_ROW_41_315 VGND VPWR sky130_fd_sc_hd__tapvpwrvgnd_1
XFILLER_10_81 VGND VGND VPWR VPWR sky130_fd_sc_hd__decap_3
XFILLER_19_133 VGND VGND VPWR VPWR sky130_fd_sc_hd__decap_3
XFILLER_19_188 VGND VGND VPWR VPWR sky130_fd_sc_hd__decap_3
X_0714_ _1235_/Q _0714_/B _0714_/C _1236_/Q VGND VGND VPWR VPWR _0718_/B sky130_fd_sc_hd__or4b_2
X_0645_ _0645_/A _1149_/Q VGND VGND VPWR VPWR _0735_/B sky130_fd_sc_hd__and2_2
X_0576_ hold160/X _1233_/D _0576_/S VGND VGND VPWR VPWR _1141_/D sky130_fd_sc_hd__mux2_1
XFILLER_15_48 VGND VGND VPWR VPWR sky130_fd_sc_hd__decap_3
XFILLER_40_106 VGND VGND VPWR VPWR sky130_fd_sc_hd__fill_2
X_1128_ _1233_/CLK _1128_/D _1042_/B1 VGND VGND VPWR VPWR _1128_/Q sky130_fd_sc_hd__dfrtp_2
X_1059_ _1061_/A1 _1061_/A2 _1067_/B1 VGND VGND VPWR VPWR _1059_/X sky130_fd_sc_hd__o21a_2
Xoutput58 _1105_/Q VGND VGND VPWR VPWR o_receive_data[7] sky130_fd_sc_hd__clkdlybuf4s25_1
Xoutput47 _1286_/X VGND VGND VPWR VPWR o_cmd_status_reg[5] sky130_fd_sc_hd__clkdlybuf4s25_1
XFILLER_0_279 VGND VGND VPWR VPWR sky130_fd_sc_hd__fill_1
XFILLER_16_103 VGND VGND VPWR VPWR sky130_fd_sc_hd__decap_3
XFILLER_48_206 VGND VGND VPWR VPWR sky130_fd_sc_hd__decap_3
XFILLER_48_239 VGND VGND VPWR VPWR sky130_fd_sc_hd__decap_3
XFILLER_47_261 VGND VGND VPWR VPWR sky130_fd_sc_hd__decap_3
XFILLER_30_172 VGND VGND VPWR VPWR sky130_fd_sc_hd__decap_3
XTAP_TAPCELL_ROW_17_197 VGND VPWR sky130_fd_sc_hd__tapvpwrvgnd_1
X_0628_ _0628_/A _0628_/B _0628_/C VGND VGND VPWR VPWR _0632_/B sky130_fd_sc_hd__or3_2
XFILLER_38_250 VGND VGND VPWR VPWR sky130_fd_sc_hd__fill_2
X_0559_ _1218_/Q VGND VGND VPWR VPWR _0559_/Y sky130_fd_sc_hd__inv_2
XFILLER_13_106 VGND VGND VPWR VPWR sky130_fd_sc_hd__decap_3
XFILLER_13_128 VGND VGND VPWR VPWR sky130_fd_sc_hd__decap_3
XFILLER_29_261 VGND VGND VPWR VPWR sky130_fd_sc_hd__fill_2
XFILLER_12_150 VGND VGND VPWR VPWR sky130_fd_sc_hd__decap_3
XFILLER_16_91 VGND VGND VPWR VPWR sky130_fd_sc_hd__decap_3
XFILLER_8_110 VGND VGND VPWR VPWR sky130_fd_sc_hd__decap_3
XFILLER_8_165 VGND VGND VPWR VPWR sky130_fd_sc_hd__decap_3
XFILLER_50_212 VGND VGND VPWR VPWR sky130_fd_sc_hd__decap_3
XFILLER_50_245 VGND VGND VPWR VPWR sky130_fd_sc_hd__decap_3
XFILLER_50_256 VGND VGND VPWR VPWR sky130_fd_sc_hd__decap_3
XFILLER_12_27 VGND VGND VPWR VPWR sky130_fd_sc_hd__fill_1
XFILLER_50_289 VGND VGND VPWR VPWR sky130_fd_sc_hd__decap_3
Xhold132 _1182_/Q VGND VGND VPWR VPWR _0849_/B sky130_fd_sc_hd__dlygate4sd3_1
Xhold143 _1262_/Q VGND VGND VPWR VPWR _1260_/D sky130_fd_sc_hd__dlygate4sd3_1
Xhold154 _0731_/Y VGND VGND VPWR VPWR _1252_/D sky130_fd_sc_hd__dlygate4sd3_1
Xhold165 _1099_/Q VGND VGND VPWR VPWR hold165/X sky130_fd_sc_hd__dlygate4sd3_1
Xhold176 _1157_/Q VGND VGND VPWR VPWR hold176/X sky130_fd_sc_hd__dlygate4sd3_1
Xhold187 _1266_/Q VGND VGND VPWR VPWR _0616_/B sky130_fd_sc_hd__dlygate4sd3_1
Xhold198 _1224_/Q VGND VGND VPWR VPWR hold198/X sky130_fd_sc_hd__dlygate4sd3_1
XTAP_TAPCELL_ROW_5_135 VGND VPWR sky130_fd_sc_hd__tapvpwrvgnd_1
XFILLER_37_46 VGND VGND VPWR VPWR sky130_fd_sc_hd__fill_1
XFILLER_37_57 VGND VGND VPWR VPWR sky130_fd_sc_hd__fill_2
XFILLER_26_275 VGND VGND VPWR VPWR sky130_fd_sc_hd__decap_3
XTAP_TAPCELL_ROW_36_292 VGND VPWR sky130_fd_sc_hd__tapvpwrvgnd_1
XFILLER_5_146 VGND VGND VPWR VPWR sky130_fd_sc_hd__decap_3
XTAP_TAPCELL_ROW_19_204 VGND VPWR sky130_fd_sc_hd__tapvpwrvgnd_1
XFILLER_17_231 VGND VGND VPWR VPWR sky130_fd_sc_hd__decap_3
XFILLER_32_256 VGND VGND VPWR VPWR sky130_fd_sc_hd__decap_3
X_0962_ _0616_/B _1267_/Q _0970_/S VGND VGND VPWR VPWR _0962_/X sky130_fd_sc_hd__mux2_1
X_0893_ _1106_/Q _0545_/Y _1212_/D _0615_/A VGND VGND VPWR VPWR _0893_/X sky130_fd_sc_hd__a22o_2
XFILLER_23_223 VGND VGND VPWR VPWR sky130_fd_sc_hd__fill_1
XFILLER_23_234 VGND VGND VPWR VPWR sky130_fd_sc_hd__decap_3
XFILLER_23_37 VGND VGND VPWR VPWR sky130_fd_sc_hd__fill_1
XFILLER_14_234 VGND VGND VPWR VPWR sky130_fd_sc_hd__decap_3
Xfanout71 _1067_/A1 VGND VGND VPWR VPWR _1053_/A1 sky130_fd_sc_hd__clkdlybuf4s25_1
Xfanout82 fanout86/X VGND VGND VPWR VPWR _1042_/A2 sky130_fd_sc_hd__clkdlybuf4s25_1
Xfanout93 _1190_/Q VGND VGND VPWR VPWR _0874_/S sky130_fd_sc_hd__clkdlybuf4s25_1
XFILLER_29_6 VGND VGND VPWR VPWR sky130_fd_sc_hd__decap_3
XFILLER_49_142 VGND VGND VPWR VPWR sky130_fd_sc_hd__decap_3
XFILLER_49_175 VGND VGND VPWR VPWR sky130_fd_sc_hd__decap_3
X_1230_ _1268_/CLK _1230_/D _1038_/X VGND VGND VPWR VPWR _1230_/Q sky130_fd_sc_hd__dfstp_2
X_1161_ _1191_/CLK _1161_/D load_slew117/X VGND VGND VPWR VPWR _1161_/Q sky130_fd_sc_hd__dfrtp_2
X_1092_ _1227_/CLK _1092_/D fanout114/X VGND VGND VPWR VPWR _1285_/A sky130_fd_sc_hd__dfrtp_2
X_0945_ _1123_/Q _0949_/D _1124_/Q VGND VGND VPWR VPWR _0947_/C sky130_fd_sc_hd__a21o_2
X_0876_ _0891_/A _1097_/Q _0875_/X VGND VGND VPWR VPWR _1097_/D sky130_fd_sc_hd__a21o_2
XFILLER_43_307 VGND VGND VPWR VPWR sky130_fd_sc_hd__fill_1
XFILLER_11_259 VGND VGND VPWR VPWR sky130_fd_sc_hd__decap_3
XFILLER_34_69 VGND VGND VPWR VPWR sky130_fd_sc_hd__decap_3
Xclkload2 clkload2/A VGND VGND VPWR VPWR clkload2/X sky130_fd_sc_hd__clkbuf_8
XFILLER_50_68 VGND VGND VPWR VPWR sky130_fd_sc_hd__decap_3
XFILLER_24_91 VGND VGND VPWR VPWR sky130_fd_sc_hd__decap_3
X_0730_ _1079_/Q _0730_/B VGND VGND VPWR VPWR _0730_/Y sky130_fd_sc_hd__nor2_2
X_0661_ _1166_/Q _1080_/Q VGND VGND VPWR VPWR _0662_/D sky130_fd_sc_hd__nand2b_2
XFILLER_27_3 VGND VGND VPWR VPWR sky130_fd_sc_hd__fill_1
X_1213_ _1226_/CLK _1213_/D _1021_/X VGND VGND VPWR VPWR _1213_/Q sky130_fd_sc_hd__dfrtp_2
X_0592_ _0592_/A _0592_/B VGND VGND VPWR VPWR _1136_/D sky130_fd_sc_hd__nor2_2
XFILLER_25_307 VGND VGND VPWR VPWR sky130_fd_sc_hd__fill_1
XFILLER_37_178 VGND VGND VPWR VPWR sky130_fd_sc_hd__decap_3
X_1144_ _1259_/CLK _1144_/D _0992_/X VGND VGND VPWR VPWR _1144_/Q sky130_fd_sc_hd__dfrtp_2
X_1075_ clkload5/A _1075_/D load_slew102/X VGND VGND VPWR VPWR _1075_/Q sky130_fd_sc_hd__dfrtp_2
Xclkbuf_leaf_15_i_clk clkload0/A VGND VGND VPWR VPWR _1227_/CLK sky130_fd_sc_hd__clkbuf_8
X_0928_ _0928_/A _0928_/B _0928_/C _0928_/D VGND VGND VPWR VPWR _0928_/X sky130_fd_sc_hd__and4_2
X_0859_ hold257/X input6/X _0861_/S VGND VGND VPWR VPWR _1087_/D sky130_fd_sc_hd__mux2_1
XFILLER_43_126 VGND VGND VPWR VPWR sky130_fd_sc_hd__fill_1
XFILLER_43_148 VGND VGND VPWR VPWR sky130_fd_sc_hd__fill_1
XFILLER_45_46 VGND VGND VPWR VPWR sky130_fd_sc_hd__decap_3
XFILLER_45_57 VGND VGND VPWR VPWR sky130_fd_sc_hd__fill_1
XFILLER_51_181 VGND VGND VPWR VPWR sky130_fd_sc_hd__decap_3
XTAP_TAPCELL_ROW_41_316 VGND VPWR sky130_fd_sc_hd__tapvpwrvgnd_1
XFILLER_6_29 VGND VGND VPWR VPWR sky130_fd_sc_hd__decap_3
XFILLER_3_299 VGND VGND VPWR VPWR sky130_fd_sc_hd__fill_1
XFILLER_19_167 VGND VGND VPWR VPWR sky130_fd_sc_hd__fill_1
X_0713_ _1068_/Q _1239_/Q VGND VGND VPWR VPWR _0714_/C sky130_fd_sc_hd__and2b_2
X_0644_ _0648_/A hold237/X _0839_/C _0551_/Y VGND VGND VPWR VPWR _1148_/D sky130_fd_sc_hd__a22o_2
X_0575_ _0575_/A _0648_/A VGND VGND VPWR VPWR _1233_/D sky130_fd_sc_hd__nor2_2
XFILLER_40_129 VGND VGND VPWR VPWR sky130_fd_sc_hd__decap_3
X_1127_ clkload3/A _1127_/D load_slew99/X VGND VGND VPWR VPWR _1127_/Q sky130_fd_sc_hd__dfrtp_2
X_1058_ _1061_/A1 _1061_/A2 _1067_/B1 VGND VGND VPWR VPWR _1058_/X sky130_fd_sc_hd__o21a_2
Xoutput59 _1191_/Q VGND VGND VPWR VPWR o_received_data_valid sky130_fd_sc_hd__clkdlybuf4s25_1
Xoutput48 _1287_/X VGND VGND VPWR VPWR o_cmd_status_reg[6] sky130_fd_sc_hd__clkdlybuf4s25_1
XPHY_EDGE_ROW_1_Right_1 VGND VGND VPWR VPWR sky130_fd_sc_hd__decap_3
XFILLER_48_218 VGND VGND VPWR VPWR sky130_fd_sc_hd__decap_3
XFILLER_47_240 VGND VGND VPWR VPWR sky130_fd_sc_hd__decap_3
XFILLER_47_284 VGND VGND VPWR VPWR sky130_fd_sc_hd__decap_3
XTAP_TAPCELL_ROW_17_198 VGND VPWR sky130_fd_sc_hd__tapvpwrvgnd_1
X_0627_ _0628_/A _0628_/C VGND VGND VPWR VPWR _1206_/D sky130_fd_sc_hd__xnor2_2
X_0558_ _1215_/Q VGND VGND VPWR VPWR _0558_/Y sky130_fd_sc_hd__inv_2
XPHY_EDGE_ROW_15_Left_67 VGND VGND VPWR VPWR sky130_fd_sc_hd__decap_3
XFILLER_26_26 VGND VGND VPWR VPWR sky130_fd_sc_hd__fill_2
XFILLER_38_262 VGND VGND VPWR VPWR sky130_fd_sc_hd__decap_3
XFILLER_42_36 VGND VGND VPWR VPWR sky130_fd_sc_hd__decap_3
XFILLER_16_70 VGND VGND VPWR VPWR sky130_fd_sc_hd__fill_1
XFILLER_29_240 VGND VGND VPWR VPWR sky130_fd_sc_hd__decap_3
XTAP_TAPCELL_ROW_14_179 VGND VPWR sky130_fd_sc_hd__tapvpwrvgnd_1
XFILLER_35_221 VGND VGND VPWR VPWR sky130_fd_sc_hd__decap_3
XFILLER_50_224 VGND VGND VPWR VPWR sky130_fd_sc_hd__decap_3
XFILLER_50_268 VGND VGND VPWR VPWR sky130_fd_sc_hd__decap_3
Xi2c_master_controller_top VGND VGND VPWR VPWR i2c_master_controller_top/HI o_cmd_status_reg[0]
+ sky130_fd_sc_hd__conb_1
Xhold133 _0849_/Y VGND VGND VPWR VPWR hold133/X sky130_fd_sc_hd__dlygate4sd3_1
Xhold144 _1158_/Q VGND VGND VPWR VPWR _1199_/D sky130_fd_sc_hd__dlygate4sd3_1
Xhold155 _1178_/Q VGND VGND VPWR VPWR _1182_/D sky130_fd_sc_hd__dlygate4sd3_1
Xhold166 _1100_/Q VGND VGND VPWR VPWR hold166/X sky130_fd_sc_hd__dlygate4sd3_1
Xhold177 _1096_/Q VGND VGND VPWR VPWR hold177/X sky130_fd_sc_hd__dlygate4sd3_1
Xhold188 _0962_/X VGND VGND VPWR VPWR _1266_/D sky130_fd_sc_hd__dlygate4sd3_1
Xhold199 _1195_/Q VGND VGND VPWR VPWR hold199/X sky130_fd_sc_hd__dlygate4sd3_1
XTAP_TAPCELL_ROW_5_136 VGND VPWR sky130_fd_sc_hd__tapvpwrvgnd_1
XFILLER_26_298 VGND VGND VPWR VPWR sky130_fd_sc_hd__fill_2
XFILLER_41_213 VGND VGND VPWR VPWR sky130_fd_sc_hd__decap_3
XTAP_TAPCELL_ROW_28_249 VGND VPWR sky130_fd_sc_hd__tapvpwrvgnd_1
XFILLER_41_279 VGND VGND VPWR VPWR sky130_fd_sc_hd__fill_1
XTAP_TAPCELL_ROW_36_293 VGND VPWR sky130_fd_sc_hd__tapvpwrvgnd_1
XFILLER_5_169 VGND VGND VPWR VPWR sky130_fd_sc_hd__decap_3
XFILLER_49_302 VGND VGND VPWR VPWR sky130_fd_sc_hd__decap_3
XTAP_TAPCELL_ROW_19_205 VGND VPWR sky130_fd_sc_hd__tapvpwrvgnd_1
XFILLER_17_243 VGND VGND VPWR VPWR sky130_fd_sc_hd__fill_1
XFILLER_17_254 VGND VGND VPWR VPWR sky130_fd_sc_hd__decap_3
XFILLER_17_287 VGND VGND VPWR VPWR sky130_fd_sc_hd__decap_3
X_0961_ hold239/X hold228/X _0970_/S VGND VGND VPWR VPWR _1265_/D sky130_fd_sc_hd__mux2_1
XFILLER_43_90 VGND VGND VPWR VPWR sky130_fd_sc_hd__decap_3
X_0892_ _0575_/A hold169/X _0892_/S VGND VGND VPWR VPWR _1105_/D sky130_fd_sc_hd__mux2_1
XTAP_TAPCELL_ROW_10_160 VGND VPWR sky130_fd_sc_hd__tapvpwrvgnd_1
XFILLER_23_268 VGND VGND VPWR VPWR sky130_fd_sc_hd__fill_1
XFILLER_23_27 VGND VGND VPWR VPWR sky130_fd_sc_hd__fill_2
XFILLER_23_49 VGND VGND VPWR VPWR sky130_fd_sc_hd__decap_3
XTAP_TAPCELL_ROW_33_274 VGND VPWR sky130_fd_sc_hd__tapvpwrvgnd_1
XPHY_EDGE_ROW_18_Left_70 VGND VGND VPWR VPWR sky130_fd_sc_hd__decap_3
XFILLER_46_305 VGND VGND VPWR VPWR sky130_fd_sc_hd__decap_3
XFILLER_14_268 VGND VGND VPWR VPWR sky130_fd_sc_hd__decap_3
XTAP_TAPCELL_ROW_24_230 VGND VPWR sky130_fd_sc_hd__tapvpwrvgnd_1
XFILLER_9_18 VGND VGND VPWR VPWR sky130_fd_sc_hd__decap_3
XFILLER_13_60 VGND VGND VPWR VPWR sky130_fd_sc_hd__decap_3
Xfanout72 fanout73/X VGND VGND VPWR VPWR _1067_/A1 sky130_fd_sc_hd__clkdlybuf4s25_1
Xfanout83 _1067_/A2 VGND VGND VPWR VPWR _1061_/A2 sky130_fd_sc_hd__clkdlybuf4s25_1
Xfanout94 _1129_/Q VGND VGND VPWR VPWR _0648_/A sky130_fd_sc_hd__clkdlybuf4s25_1
XFILLER_37_305 VGND VGND VPWR VPWR sky130_fd_sc_hd__decap_3
XFILLER_49_154 VGND VGND VPWR VPWR sky130_fd_sc_hd__decap_3
XFILLER_49_187 VGND VGND VPWR VPWR sky130_fd_sc_hd__decap_3
X_1160_ _1192_/CLK _1160_/D load_slew117/X VGND VGND VPWR VPWR _1160_/Q sky130_fd_sc_hd__dfrtp_2
X_1091_ _1227_/CLK _1091_/D fanout114/X VGND VGND VPWR VPWR _1284_/A sky130_fd_sc_hd__dfrtp_2
XTAP_TAPCELL_ROW_47_344 VGND VPWR sky130_fd_sc_hd__tapvpwrvgnd_1
X_0944_ _0956_/A _0944_/B _0944_/C VGND VGND VPWR VPWR _1123_/D sky130_fd_sc_hd__and3_2
X_0875_ _0648_/A _1119_/Q _1266_/Q VGND VGND VPWR VPWR _0875_/X sky130_fd_sc_hd__a21bo_2
XFILLER_9_272 VGND VGND VPWR VPWR sky130_fd_sc_hd__fill_1
XFILLER_18_27 VGND VGND VPWR VPWR sky130_fd_sc_hd__fill_1
XTAP_TAPCELL_ROW_38_300 VGND VPWR sky130_fd_sc_hd__tapvpwrvgnd_1
X_1289_ _1289_/A _0975_/X VGND VGND VPWR VPWR io_scl sky130_fd_sc_hd__ebufn_2
Xclkload3 clkload3/A VGND VGND VPWR VPWR clkload3/Y sky130_fd_sc_hd__clkinv_2
XPHY_EDGE_ROW_3_Left_55 VGND VGND VPWR VPWR sky130_fd_sc_hd__decap_3
XFILLER_19_305 VGND VGND VPWR VPWR sky130_fd_sc_hd__decap_3
XFILLER_24_81 VGND VGND VPWR VPWR sky130_fd_sc_hd__decap_3
XFILLER_10_260 VGND VGND VPWR VPWR sky130_fd_sc_hd__decap_3
X_0660_ _1161_/Q _1166_/Q VGND VGND VPWR VPWR _0678_/B sky130_fd_sc_hd__or2_2
X_0591_ hold281/X _0580_/X _0600_/B VGND VGND VPWR VPWR _0592_/B sky130_fd_sc_hd__o21ai_2
XFILLER_37_113 VGND VGND VPWR VPWR sky130_fd_sc_hd__decap_3
X_1212_ _1212_/CLK _1212_/D _1020_/X VGND VGND VPWR VPWR _1212_/Q sky130_fd_sc_hd__dfrtp_2
X_1143_ clkload8/A _1143_/D _0991_/X VGND VGND VPWR VPWR _1143_/Q sky130_fd_sc_hd__dfrtp_2
X_1074_ clkload5/A _1074_/D load_slew96/X VGND VGND VPWR VPWR _1074_/Q sky130_fd_sc_hd__dfrtp_2
X_0927_ _0927_/A _0927_/B _0927_/C _0927_/D VGND VGND VPWR VPWR _0927_/X sky130_fd_sc_hd__and4_2
X_0858_ hold272/X input5/X _0860_/S VGND VGND VPWR VPWR _1086_/D sky130_fd_sc_hd__mux2_1
X_0789_ _1236_/Q _1235_/Q VGND VGND VPWR VPWR _0791_/B sky130_fd_sc_hd__or2_2
XPHY_EDGE_ROW_45_Left_97 VGND VGND VPWR VPWR sky130_fd_sc_hd__decap_3
XFILLER_43_105 VGND VGND VPWR VPWR sky130_fd_sc_hd__decap_3
XFILLER_51_193 VGND VGND VPWR VPWR sky130_fd_sc_hd__decap_3
XTAP_TAPCELL_ROW_41_317 VGND VPWR sky130_fd_sc_hd__tapvpwrvgnd_1
XFILLER_6_19 VGND VGND VPWR VPWR sky130_fd_sc_hd__fill_1
XFILLER_10_72 VGND VGND VPWR VPWR sky130_fd_sc_hd__decap_3
XFILLER_10_94 VGND VGND VPWR VPWR sky130_fd_sc_hd__decap_3
XFILLER_19_113 VGND VGND VPWR VPWR sky130_fd_sc_hd__fill_2
XFILLER_3_278 VGND VGND VPWR VPWR sky130_fd_sc_hd__fill_2
XFILLER_3_289 VGND VGND VPWR VPWR sky130_fd_sc_hd__decap_3
XFILLER_42_171 VGND VGND VPWR VPWR sky130_fd_sc_hd__decap_3
X_0712_ _1237_/Q _1240_/Q _1242_/Q _1238_/Q VGND VGND VPWR VPWR _0714_/B sky130_fd_sc_hd__or4b_2
X_0643_ _0648_/A hold191/X _1145_/Q _1194_/Q VGND VGND VPWR VPWR _0643_/X sky130_fd_sc_hd__a22o_2
X_0574_ io_scl VGND VGND VPWR VPWR _1259_/D sky130_fd_sc_hd__inv_2
X_1126_ clkload3/A _1126_/D load_slew99/X VGND VGND VPWR VPWR _1126_/Q sky130_fd_sc_hd__dfrtp_2
XFILLER_15_39 VGND VGND VPWR VPWR sky130_fd_sc_hd__decap_3
XFILLER_21_300 VGND VGND VPWR VPWR sky130_fd_sc_hd__decap_3
XFILLER_25_127 VGND VGND VPWR VPWR sky130_fd_sc_hd__fill_1
X_1057_ _1061_/A1 _1061_/A2 _1067_/B1 VGND VGND VPWR VPWR _1057_/X sky130_fd_sc_hd__o21a_2
Xoutput49 _1288_/X VGND VGND VPWR VPWR o_cmd_status_reg[7] sky130_fd_sc_hd__clkdlybuf4s25_1
XFILLER_16_138 VGND VGND VPWR VPWR sky130_fd_sc_hd__fill_2
XFILLER_16_149 VGND VGND VPWR VPWR sky130_fd_sc_hd__fill_2
XFILLER_24_182 VGND VGND VPWR VPWR sky130_fd_sc_hd__decap_3
XFILLER_21_60 VGND VGND VPWR VPWR sky130_fd_sc_hd__decap_3
XFILLER_39_219 VGND VGND VPWR VPWR sky130_fd_sc_hd__decap_3
XFILLER_47_252 VGND VGND VPWR VPWR sky130_fd_sc_hd__decap_3
XFILLER_47_274 VGND VGND VPWR VPWR sky130_fd_sc_hd__decap_3
XFILLER_47_296 VGND VGND VPWR VPWR sky130_fd_sc_hd__decap_3
Xclkbuf_leaf_14_i_clk clkload0/A VGND VGND VPWR VPWR _1262_/CLK sky130_fd_sc_hd__clkbuf_8
XFILLER_30_163 VGND VGND VPWR VPWR sky130_fd_sc_hd__decap_3
X_0626_ _0628_/C _0626_/B VGND VGND VPWR VPWR _1205_/D sky130_fd_sc_hd__nand2_2
X_0557_ _1195_/Q VGND VGND VPWR VPWR _0557_/Y sky130_fd_sc_hd__inv_2
XPHY_EDGE_ROW_15_Right_15 VGND VGND VPWR VPWR sky130_fd_sc_hd__decap_3
XFILLER_38_285 VGND VGND VPWR VPWR sky130_fd_sc_hd__decap_3
X_1109_ _1233_/CLK _1109_/D load_slew115/X VGND VGND VPWR VPWR _1109_/Q sky130_fd_sc_hd__dfrtp_2
XPHY_EDGE_ROW_24_Right_24 VGND VGND VPWR VPWR sky130_fd_sc_hd__decap_3
XFILLER_42_26 VGND VGND VPWR VPWR sky130_fd_sc_hd__fill_2
XPHY_EDGE_ROW_33_Right_33 VGND VGND VPWR VPWR sky130_fd_sc_hd__decap_3
XFILLER_29_252 VGND VGND VPWR VPWR sky130_fd_sc_hd__decap_3
XFILLER_44_200 VGND VGND VPWR VPWR sky130_fd_sc_hd__fill_1
XPHY_EDGE_ROW_42_Right_42 VGND VGND VPWR VPWR sky130_fd_sc_hd__decap_3
XPHY_EDGE_ROW_32_Left_84 VGND VGND VPWR VPWR sky130_fd_sc_hd__decap_3
XFILLER_12_174 VGND VGND VPWR VPWR sky130_fd_sc_hd__decap_3
XFILLER_32_70 VGND VGND VPWR VPWR sky130_fd_sc_hd__fill_2
XPHY_EDGE_ROW_51_Right_51 VGND VGND VPWR VPWR sky130_fd_sc_hd__decap_3
XFILLER_35_233 VGND VGND VPWR VPWR sky130_fd_sc_hd__fill_1
XFILLER_12_18 VGND VGND VPWR VPWR sky130_fd_sc_hd__fill_1
XFILLER_50_203 VGND VGND VPWR VPWR sky130_fd_sc_hd__decap_3
XFILLER_50_236 VGND VGND VPWR VPWR sky130_fd_sc_hd__decap_3
Xhold134 _1256_/Q VGND VGND VPWR VPWR _1255_/D sky130_fd_sc_hd__dlygate4sd3_1
Xhold145 _1255_/Q VGND VGND VPWR VPWR _1254_/D sky130_fd_sc_hd__dlygate4sd3_1
Xhold156 _1167_/Q VGND VGND VPWR VPWR _1192_/D sky130_fd_sc_hd__dlygate4sd3_1
Xhold167 _1098_/Q VGND VGND VPWR VPWR hold167/X sky130_fd_sc_hd__dlygate4sd3_1
Xhold178 _1140_/Q VGND VGND VPWR VPWR hold178/X sky130_fd_sc_hd__dlygate4sd3_1
Xhold189 _1115_/Q VGND VGND VPWR VPWR hold189/X sky130_fd_sc_hd__dlygate4sd3_1
X_0609_ _1077_/Q _0609_/B _0609_/C VGND VGND VPWR VPWR _0609_/X sky130_fd_sc_hd__or3_2
XTAP_TAPCELL_ROW_5_137 VGND VPWR sky130_fd_sc_hd__tapvpwrvgnd_1
XFILLER_26_266 VGND VGND VPWR VPWR sky130_fd_sc_hd__decap_3
XFILLER_41_225 VGND VGND VPWR VPWR sky130_fd_sc_hd__decap_3
XFILLER_41_258 VGND VGND VPWR VPWR sky130_fd_sc_hd__decap_3
XFILLER_17_222 VGND VGND VPWR VPWR sky130_fd_sc_hd__fill_2
XTAP_TAPCELL_ROW_19_206 VGND VPWR sky130_fd_sc_hd__tapvpwrvgnd_1
XFILLER_17_266 VGND VGND VPWR VPWR sky130_fd_sc_hd__decap_3
XFILLER_17_277 VGND VGND VPWR VPWR sky130_fd_sc_hd__decap_3
X_0960_ hold246/X hold235/X _0970_/S VGND VGND VPWR VPWR _1264_/D sky130_fd_sc_hd__mux2_1
XFILLER_40_291 VGND VGND VPWR VPWR sky130_fd_sc_hd__fill_2
X_0891_ _0891_/A _1172_/Q VGND VGND VPWR VPWR _0892_/S sky130_fd_sc_hd__nand2_2
XTAP_TAPCELL_ROW_10_161 VGND VPWR sky130_fd_sc_hd__tapvpwrvgnd_1
XFILLER_23_214 VGND VGND VPWR VPWR sky130_fd_sc_hd__decap_3
XFILLER_23_225 VGND VGND VPWR VPWR sky130_fd_sc_hd__decap_3
XTAP_TAPCELL_ROW_33_275 VGND VPWR sky130_fd_sc_hd__tapvpwrvgnd_1
XFILLER_3_9 VGND VGND VPWR VPWR sky130_fd_sc_hd__fill_1
XFILLER_48_14 VGND VGND VPWR VPWR sky130_fd_sc_hd__fill_1
XFILLER_14_225 VGND VGND VPWR VPWR sky130_fd_sc_hd__decap_3
Xfanout62 _1064_/A1 VGND VGND VPWR VPWR _1017_/A1 sky130_fd_sc_hd__clkdlybuf4s25_1
Xfanout73 _0570_/Y VGND VGND VPWR VPWR fanout73/X sky130_fd_sc_hd__clkdlybuf4s25_1
XTAP_TAPCELL_ROW_24_231 VGND VPWR sky130_fd_sc_hd__tapvpwrvgnd_1
Xfanout84 _1067_/A2 VGND VGND VPWR VPWR _1053_/A2 sky130_fd_sc_hd__clkdlybuf4s25_1
Xfanout95 fanout98/A VGND VGND VPWR VPWR fanout95/X sky130_fd_sc_hd__clkdlybuf4s25_1
XFILLER_49_111 VGND VGND VPWR VPWR sky130_fd_sc_hd__fill_1
XFILLER_49_166 VGND VGND VPWR VPWR sky130_fd_sc_hd__fill_2
XFILLER_49_199 VGND VGND VPWR VPWR sky130_fd_sc_hd__decap_3
X_1090_ _1262_/CLK _1090_/D _1036_/B1 VGND VGND VPWR VPWR _1283_/A sky130_fd_sc_hd__dfrtp_2
XTAP_TAPCELL_ROW_47_345 VGND VPWR sky130_fd_sc_hd__tapvpwrvgnd_1
Xclkload10 _1240_/CLK VGND VGND VPWR VPWR clkload10/Y sky130_fd_sc_hd__clkinv_2
X_0943_ _1123_/Q _0949_/D VGND VGND VPWR VPWR _0944_/C sky130_fd_sc_hd__or2_2
X_0874_ hold177/X input18/X _0874_/S VGND VGND VPWR VPWR _1096_/D sky130_fd_sc_hd__mux2_1
XFILLER_28_306 VGND VGND VPWR VPWR sky130_fd_sc_hd__fill_2
X_1288_ _1288_/A VGND VGND VPWR VPWR _1288_/X sky130_fd_sc_hd__buf_2
XTAP_TAPCELL_ROW_38_301 VGND VPWR sky130_fd_sc_hd__tapvpwrvgnd_1
XFILLER_11_228 VGND VGND VPWR VPWR sky130_fd_sc_hd__decap_3
XFILLER_34_27 VGND VGND VPWR VPWR sky130_fd_sc_hd__fill_1
XFILLER_50_26 VGND VGND VPWR VPWR sky130_fd_sc_hd__fill_2
XFILLER_50_59 VGND VGND VPWR VPWR sky130_fd_sc_hd__decap_3
Xclkload4 clkload4/A VGND VGND VPWR VPWR clkload4/X sky130_fd_sc_hd__clkbuf_8
XFILLER_46_158 VGND VGND VPWR VPWR sky130_fd_sc_hd__decap_3
XFILLER_10_250 VGND VGND VPWR VPWR sky130_fd_sc_hd__fill_2
X_0590_ hold279/X _0592_/A _0589_/Y VGND VGND VPWR VPWR _1137_/D sky130_fd_sc_hd__a21oi_2
XFILLER_34_6 VGND VGND VPWR VPWR sky130_fd_sc_hd__fill_1
X_1211_ _1211_/CLK _1211_/D _1019_/X VGND VGND VPWR VPWR _1211_/Q sky130_fd_sc_hd__dfrtp_2
X_1142_ _1236_/CLK _1142_/D _0990_/X VGND VGND VPWR VPWR _1142_/Q sky130_fd_sc_hd__dfstp_2
XFILLER_37_158 VGND VGND VPWR VPWR sky130_fd_sc_hd__fill_1
XFILLER_37_169 VGND VGND VPWR VPWR sky130_fd_sc_hd__decap_3
X_1073_ clkload5/A _1073_/D load_slew96/X VGND VGND VPWR VPWR _1073_/Q sky130_fd_sc_hd__dfrtp_2
XFILLER_20_29 VGND VGND VPWR VPWR sky130_fd_sc_hd__fill_1
X_0926_ _1083_/Q _1121_/Q VGND VGND VPWR VPWR _0927_/D sky130_fd_sc_hd__xnor2_2
X_0857_ hold264/X input4/X _0861_/S VGND VGND VPWR VPWR _1085_/D sky130_fd_sc_hd__mux2_1
X_0788_ _0718_/A _0718_/B _0718_/C _0822_/A VGND VGND VPWR VPWR _0804_/A sky130_fd_sc_hd__o31a_2
XFILLER_51_150 VGND VGND VPWR VPWR sky130_fd_sc_hd__decap_3
XFILLER_51_172 VGND VGND VPWR VPWR sky130_fd_sc_hd__decap_3
XTAP_TAPCELL_ROW_41_318 VGND VPWR sky130_fd_sc_hd__tapvpwrvgnd_1
XFILLER_19_136 VGND VGND VPWR VPWR sky130_fd_sc_hd__decap_3
XFILLER_19_169 VGND VGND VPWR VPWR sky130_fd_sc_hd__decap_3
XFILLER_42_150 VGND VGND VPWR VPWR sky130_fd_sc_hd__decap_3
X_0711_ _1068_/Q _0564_/Y _0709_/X _0710_/X VGND VGND VPWR VPWR _0718_/A sky130_fd_sc_hd__a211o_2
XFILLER_32_3 VGND VGND VPWR VPWR sky130_fd_sc_hd__decap_3
X_0642_ _0645_/A _1150_/Q _0735_/A VGND VGND VPWR VPWR _0642_/X sky130_fd_sc_hd__a21o_2
X_0573_ io_sda VGND VGND VPWR VPWR _1256_/D sky130_fd_sc_hd__inv_2
X_1125_ clkload3/A _1125_/D load_slew99/X VGND VGND VPWR VPWR _1125_/Q sky130_fd_sc_hd__dfrtp_2
X_1056_ _1067_/A1 _1067_/A2 _1061_/B1 VGND VGND VPWR VPWR _1056_/X sky130_fd_sc_hd__o21a_2
X_0909_ _1072_/Q input39/X _0917_/S VGND VGND VPWR VPWR _0909_/X sky130_fd_sc_hd__mux2_1
XFILLER_0_249 VGND VGND VPWR VPWR sky130_fd_sc_hd__decap_3
XFILLER_48_209 VGND VGND VPWR VPWR sky130_fd_sc_hd__decap_3
XFILLER_21_83 VGND VGND VPWR VPWR sky130_fd_sc_hd__decap_3
XFILLER_21_94 VGND VGND VPWR VPWR sky130_fd_sc_hd__decap_3
XFILLER_47_220 VGND VGND VPWR VPWR sky130_fd_sc_hd__decap_3
XFILLER_47_231 VGND VGND VPWR VPWR sky130_fd_sc_hd__decap_3
XFILLER_47_264 VGND VGND VPWR VPWR sky130_fd_sc_hd__decap_3
XFILLER_15_172 VGND VGND VPWR VPWR sky130_fd_sc_hd__fill_1
XFILLER_30_175 VGND VGND VPWR VPWR sky130_fd_sc_hd__decap_3
XFILLER_30_197 VGND VGND VPWR VPWR sky130_fd_sc_hd__decap_3
X_0625_ _0623_/A _0623_/B input13/X VGND VGND VPWR VPWR _0626_/B sky130_fd_sc_hd__o21ai_2
X_0556_ _1110_/Q VGND VGND VPWR VPWR _0556_/Y sky130_fd_sc_hd__inv_2
XFILLER_13_109 VGND VGND VPWR VPWR sky130_fd_sc_hd__decap_3
XFILLER_38_253 VGND VGND VPWR VPWR sky130_fd_sc_hd__decap_3
X_1108_ _1192_/CLK _1108_/D load_slew115/X VGND VGND VPWR VPWR _1108_/Q sky130_fd_sc_hd__dfrtp_2
X_1039_ _1042_/A1 _1042_/A2 _1042_/B1 VGND VGND VPWR VPWR _1039_/X sky130_fd_sc_hd__o21a_2
XFILLER_29_231 VGND VGND VPWR VPWR sky130_fd_sc_hd__fill_2
XFILLER_16_61 VGND VGND VPWR VPWR sky130_fd_sc_hd__decap_3
XFILLER_16_94 VGND VGND VPWR VPWR sky130_fd_sc_hd__decap_3
XFILLER_32_93 VGND VGND VPWR VPWR sky130_fd_sc_hd__decap_3
XFILLER_8_168 VGND VGND VPWR VPWR sky130_fd_sc_hd__decap_3
XFILLER_8_113 VGND VGND VPWR VPWR sky130_fd_sc_hd__decap_3
XFILLER_50_215 VGND VGND VPWR VPWR sky130_fd_sc_hd__decap_3
XFILLER_50_248 VGND VGND VPWR VPWR sky130_fd_sc_hd__decap_3
XFILLER_50_259 VGND VGND VPWR VPWR sky130_fd_sc_hd__decap_3
Xhold135 _1261_/Q VGND VGND VPWR VPWR _1262_/D sky130_fd_sc_hd__dlygate4sd3_1
Xhold146 _1078_/Q VGND VGND VPWR VPWR _0730_/B sky130_fd_sc_hd__dlygate4sd3_1
Xhold157 _1189_/Q VGND VGND VPWR VPWR hold157/X sky130_fd_sc_hd__dlygate4sd3_1
Xhold168 _1233_/Q VGND VGND VPWR VPWR _0736_/A sky130_fd_sc_hd__dlygate4sd3_1
Xhold179 _0602_/Y VGND VGND VPWR VPWR _1131_/D sky130_fd_sc_hd__dlygate4sd3_1
X_0608_ _1285_/A _1284_/A _0607_/X _1095_/Q _1096_/Q VGND VGND VPWR VPWR _0609_/C
+ sky130_fd_sc_hd__o32a_2
X_0539_ _0648_/A VGND VGND VPWR VPWR _0645_/A sky130_fd_sc_hd__inv_2
XTAP_TAPCELL_ROW_5_138 VGND VPWR sky130_fd_sc_hd__tapvpwrvgnd_1
XFILLER_26_278 VGND VGND VPWR VPWR sky130_fd_sc_hd__fill_1
XFILLER_5_149 VGND VGND VPWR VPWR sky130_fd_sc_hd__fill_2
XFILLER_1_300 VGND VGND VPWR VPWR sky130_fd_sc_hd__decap_3
Xclkbuf_leaf_13_i_clk clkload0/A VGND VGND VPWR VPWR _1226_/CLK sky130_fd_sc_hd__clkbuf_8
XFILLER_17_234 VGND VGND VPWR VPWR sky130_fd_sc_hd__decap_3
XFILLER_27_60 VGND VGND VPWR VPWR sky130_fd_sc_hd__fill_1
XTAP_TAPCELL_ROW_19_207 VGND VPWR sky130_fd_sc_hd__tapvpwrvgnd_1
XFILLER_32_248 VGND VGND VPWR VPWR sky130_fd_sc_hd__decap_3
XFILLER_32_259 VGND VGND VPWR VPWR sky130_fd_sc_hd__decap_3
XFILLER_43_81 VGND VGND VPWR VPWR sky130_fd_sc_hd__decap_3
X_0890_ _0575_/A hold163/X _0890_/S VGND VGND VPWR VPWR _1104_/D sky130_fd_sc_hd__mux2_1
XFILLER_4_182 VGND VGND VPWR VPWR sky130_fd_sc_hd__decap_3
XTAP_TAPCELL_ROW_10_162 VGND VPWR sky130_fd_sc_hd__tapvpwrvgnd_1
XTAP_TAPCELL_ROW_2_119 VGND VPWR sky130_fd_sc_hd__tapvpwrvgnd_1
XFILLER_23_237 VGND VGND VPWR VPWR sky130_fd_sc_hd__decap_3
XTAP_TAPCELL_ROW_33_276 VGND VPWR sky130_fd_sc_hd__tapvpwrvgnd_1
Xfanout63 _1038_/A1 VGND VGND VPWR VPWR _1064_/A1 sky130_fd_sc_hd__clkdlybuf4s25_1
Xfanout74 _0645_/A VGND VGND VPWR VPWR _0891_/A sky130_fd_sc_hd__clkdlybuf4s25_1
Xfanout85 fanout86/X VGND VGND VPWR VPWR _1067_/A2 sky130_fd_sc_hd__clkdlybuf4s25_1
XTAP_TAPCELL_ROW_24_232 VGND VPWR sky130_fd_sc_hd__tapvpwrvgnd_1
XFILLER_29_9 VGND VGND VPWR VPWR sky130_fd_sc_hd__fill_1
XFILLER_49_145 VGND VGND VPWR VPWR sky130_fd_sc_hd__decap_3
XFILLER_49_178 VGND VGND VPWR VPWR sky130_fd_sc_hd__decap_3
XTAP_TAPCELL_ROW_47_346 VGND VPWR sky130_fd_sc_hd__tapvpwrvgnd_1
XFILLER_13_292 VGND VGND VPWR VPWR sky130_fd_sc_hd__fill_1
Xclkload11 _1236_/CLK VGND VGND VPWR VPWR clkload11/X sky130_fd_sc_hd__clkbuf_4
X_0942_ _1123_/Q _0949_/D VGND VGND VPWR VPWR _0944_/B sky130_fd_sc_hd__nand2_2
X_0873_ hold180/X input19/X _0874_/S VGND VGND VPWR VPWR _1095_/D sky130_fd_sc_hd__mux2_1
XFILLER_9_263 VGND VGND VPWR VPWR sky130_fd_sc_hd__decap_3
XFILLER_18_29 VGND VGND VPWR VPWR sky130_fd_sc_hd__fill_2
X_1287_ _1287_/A VGND VGND VPWR VPWR _1287_/X sky130_fd_sc_hd__buf_2
XTAP_TAPCELL_ROW_38_302 VGND VPWR sky130_fd_sc_hd__tapvpwrvgnd_1
Xclkload5 clkload5/A VGND VGND VPWR VPWR clkload5/X sky130_fd_sc_hd__clkbuf_8
XFILLER_46_104 VGND VGND VPWR VPWR sky130_fd_sc_hd__decap_3
XFILLER_24_94 VGND VGND VPWR VPWR sky130_fd_sc_hd__decap_3
XFILLER_40_93 VGND VGND VPWR VPWR sky130_fd_sc_hd__decap_3
X_1210_ clkload7/A _1210_/D _1018_/X VGND VGND VPWR VPWR _1210_/Q sky130_fd_sc_hd__dfstp_2
X_1141_ _1212_/CLK _1141_/D _0989_/X VGND VGND VPWR VPWR _1141_/Q sky130_fd_sc_hd__dfrtp_2
X_1072_ clkload5/A _1072_/D fanout95/X VGND VGND VPWR VPWR _1072_/Q sky130_fd_sc_hd__dfrtp_2
XFILLER_45_192 VGND VGND VPWR VPWR sky130_fd_sc_hd__decap_3
Xclkbuf_2_2__f_i_clk clkbuf_0_i_clk/X VGND VGND VPWR VPWR clkload1/A sky130_fd_sc_hd__clkbuf_16
X_0925_ _1089_/Q _1127_/Q VGND VGND VPWR VPWR _0927_/C sky130_fd_sc_hd__xnor2_2
X_0856_ hold262/X input3/X _0861_/S VGND VGND VPWR VPWR _1084_/D sky130_fd_sc_hd__mux2_1
X_0787_ hold242/X _1251_/D _0822_/A VGND VGND VPWR VPWR _1235_/D sky130_fd_sc_hd__o21ai_2
XFILLER_36_170 VGND VGND VPWR VPWR sky130_fd_sc_hd__decap_3
XFILLER_45_49 VGND VGND VPWR VPWR sky130_fd_sc_hd__decap_3
XFILLER_51_162 VGND VGND VPWR VPWR sky130_fd_sc_hd__decap_3
XFILLER_51_184 VGND VGND VPWR VPWR sky130_fd_sc_hd__decap_3
XFILLER_42_162 VGND VGND VPWR VPWR sky130_fd_sc_hd__decap_3
XFILLER_51_81 VGND VGND VPWR VPWR sky130_fd_sc_hd__decap_3
X_0710_ _1069_/Q _1241_/Q VGND VGND VPWR VPWR _0710_/X sky130_fd_sc_hd__and2b_2
X_0641_ hold171/X _1229_/Q _0613_/Y _0614_/A VGND VGND VPWR VPWR _0641_/X sky130_fd_sc_hd__a22o_2
XFILLER_25_3 VGND VGND VPWR VPWR sky130_fd_sc_hd__decap_3
X_0572_ _0815_/A VGND VGND VPWR VPWR _0822_/A sky130_fd_sc_hd__inv_2
X_1124_ clkload3/A _1124_/D load_slew99/X VGND VGND VPWR VPWR _1124_/Q sky130_fd_sc_hd__dfrtp_2
X_1055_ _1067_/A1 _1067_/A2 _1055_/B1 VGND VGND VPWR VPWR _1055_/X sky130_fd_sc_hd__o21a_2
X_0908_ hold201/X _0677_/Y _0903_/Y _0907_/X VGND VGND VPWR VPWR _1113_/D sky130_fd_sc_hd__a22o_2
X_0839_ _1150_/Q _1146_/Q _0839_/C VGND VGND VPWR VPWR _0839_/Y sky130_fd_sc_hd__nor3_2
XFILLER_12_302 VGND VGND VPWR VPWR sky130_fd_sc_hd__decap_3
XFILLER_46_81 VGND VGND VPWR VPWR sky130_fd_sc_hd__decap_3
XFILLER_47_243 VGND VGND VPWR VPWR sky130_fd_sc_hd__decap_3
XFILLER_47_287 VGND VGND VPWR VPWR sky130_fd_sc_hd__decap_3
X_0624_ input9/X _0621_/A _0621_/B _0623_/A input13/X VGND VGND VPWR VPWR _0628_/C
+ sky130_fd_sc_hd__a2111o_2
XFILLER_7_53 VGND VGND VPWR VPWR sky130_fd_sc_hd__decap_3
X_0555_ _1185_/Q VGND VGND VPWR VPWR _0555_/Y sky130_fd_sc_hd__inv_2
XFILLER_26_29 VGND VGND VPWR VPWR sky130_fd_sc_hd__decap_3
XFILLER_38_265 VGND VGND VPWR VPWR sky130_fd_sc_hd__decap_3
XFILLER_38_276 VGND VGND VPWR VPWR sky130_fd_sc_hd__fill_1
XFILLER_38_298 VGND VGND VPWR VPWR sky130_fd_sc_hd__decap_3
X_1107_ _1233_/CLK _1107_/D fanout119/X VGND VGND VPWR VPWR _1288_/A sky130_fd_sc_hd__dfrtp_2
X_1038_ _1038_/A1 _1038_/A2 _1060_/B1 VGND VGND VPWR VPWR _1038_/X sky130_fd_sc_hd__o21a_2
XPHY_EDGE_ROW_5_Right_5 VGND VGND VPWR VPWR sky130_fd_sc_hd__decap_3
XFILLER_42_39 VGND VGND VPWR VPWR sky130_fd_sc_hd__decap_3
XTAP_TAPCELL_ROW_16_190 VGND VPWR sky130_fd_sc_hd__tapvpwrvgnd_1
XFILLER_29_210 VGND VGND VPWR VPWR sky130_fd_sc_hd__decap_3
XFILLER_29_221 VGND VGND VPWR VPWR sky130_fd_sc_hd__decap_3
XFILLER_29_243 VGND VGND VPWR VPWR sky130_fd_sc_hd__decap_3
XFILLER_50_227 VGND VGND VPWR VPWR sky130_fd_sc_hd__decap_3
Xhold136 _1184_/Q VGND VGND VPWR VPWR _1185_/D sky130_fd_sc_hd__dlygate4sd3_1
Xhold147 _0730_/Y VGND VGND VPWR VPWR _1069_/D sky130_fd_sc_hd__dlygate4sd3_1
Xhold158 _0640_/Y VGND VGND VPWR VPWR _1142_/D sky130_fd_sc_hd__dlygate4sd3_1
Xhold169 _1105_/Q VGND VGND VPWR VPWR hold169/X sky130_fd_sc_hd__dlygate4sd3_1
X_0607_ _1287_/A _1286_/A _1288_/A VGND VGND VPWR VPWR _0607_/X sky130_fd_sc_hd__o21ba_2
X_0538_ _1130_/Q VGND VGND VPWR VPWR _0575_/A sky130_fd_sc_hd__inv_2
Xclkbuf_leaf_9_i_clk clkload2/A VGND VGND VPWR VPWR _1259_/CLK sky130_fd_sc_hd__clkbuf_8
XFILLER_34_290 VGND VGND VPWR VPWR sky130_fd_sc_hd__fill_2
XFILLER_41_216 VGND VGND VPWR VPWR sky130_fd_sc_hd__decap_3
XFILLER_49_305 VGND VGND VPWR VPWR sky130_fd_sc_hd__decap_3
XFILLER_17_202 VGND VGND VPWR VPWR sky130_fd_sc_hd__decap_3
XFILLER_17_257 VGND VGND VPWR VPWR sky130_fd_sc_hd__decap_3
XTAP_TAPCELL_ROW_19_208 VGND VPWR sky130_fd_sc_hd__tapvpwrvgnd_1
XFILLER_43_60 VGND VGND VPWR VPWR sky130_fd_sc_hd__decap_3
XFILLER_43_93 VGND VGND VPWR VPWR sky130_fd_sc_hd__decap_3
XTAP_TAPCELL_ROW_10_163 VGND VPWR sky130_fd_sc_hd__tapvpwrvgnd_1
XTAP_TAPCELL_ROW_33_277 VGND VPWR sky130_fd_sc_hd__tapvpwrvgnd_1
XFILLER_13_63 VGND VGND VPWR VPWR sky130_fd_sc_hd__fill_1
Xfanout64 _1038_/A1 VGND VGND VPWR VPWR _1063_/A1 sky130_fd_sc_hd__clkdlybuf4s25_1
Xfanout75 _1064_/A2 VGND VGND VPWR VPWR _1017_/A2 sky130_fd_sc_hd__clkdlybuf4s25_1
Xfanout86 _1260_/Q VGND VGND VPWR VPWR fanout86/X sky130_fd_sc_hd__clkdlybuf4s25_1
Xfanout97 fanout98/A VGND VGND VPWR VPWR fanout97/X sky130_fd_sc_hd__clkdlybuf4s25_1
XTAP_TAPCELL_ROW_24_233 VGND VPWR sky130_fd_sc_hd__tapvpwrvgnd_1
XFILLER_49_102 VGND VGND VPWR VPWR sky130_fd_sc_hd__decap_3
XFILLER_49_113 VGND VGND VPWR VPWR sky130_fd_sc_hd__fill_1
XFILLER_49_157 VGND VGND VPWR VPWR sky130_fd_sc_hd__decap_3
X_0941_ _0949_/D _0941_/B _0956_/A VGND VGND VPWR VPWR _1122_/D sky130_fd_sc_hd__and3b_2
XTAP_TAPCELL_ROW_47_347 VGND VPWR sky130_fd_sc_hd__tapvpwrvgnd_1
X_0872_ hold225/X _0871_/X _0862_/Y VGND VGND VPWR VPWR _1094_/D sky130_fd_sc_hd__o21a_2
XFILLER_9_231 VGND VGND VPWR VPWR sky130_fd_sc_hd__decap_3
XPHY_EDGE_ROW_50_Left_102 VGND VGND VPWR VPWR sky130_fd_sc_hd__decap_3
X_1286_ _1286_/A VGND VGND VPWR VPWR _1286_/X sky130_fd_sc_hd__buf_2
XTAP_TAPCELL_ROW_38_303 VGND VPWR sky130_fd_sc_hd__tapvpwrvgnd_1
XFILLER_34_29 VGND VGND VPWR VPWR sky130_fd_sc_hd__decap_3
Xclkbuf_leaf_12_i_clk clkload2/A VGND VGND VPWR VPWR _1236_/CLK sky130_fd_sc_hd__clkbuf_8
Xclkload6 clkload6/A VGND VGND VPWR VPWR clkload6/X sky130_fd_sc_hd__clkbuf_4
XTAP_TAPCELL_ROW_21_214 VGND VPWR sky130_fd_sc_hd__tapvpwrvgnd_1
XFILLER_46_149 VGND VGND VPWR VPWR sky130_fd_sc_hd__decap_3
XFILLER_24_51 VGND VGND VPWR VPWR sky130_fd_sc_hd__decap_3
XFILLER_10_263 VGND VGND VPWR VPWR sky130_fd_sc_hd__decap_3
XFILLER_49_70 VGND VGND VPWR VPWR sky130_fd_sc_hd__decap_3
XFILLER_1_66 VGND VGND VPWR VPWR sky130_fd_sc_hd__fill_1
XFILLER_1_88 VGND VGND VPWR VPWR sky130_fd_sc_hd__decap_3
XFILLER_37_116 VGND VGND VPWR VPWR sky130_fd_sc_hd__fill_2
XFILLER_37_138 VGND VGND VPWR VPWR sky130_fd_sc_hd__decap_3
X_1140_ clkload7/A _1140_/D _0988_/X VGND VGND VPWR VPWR _1140_/Q sky130_fd_sc_hd__dfrtp_2
X_1071_ clkload5/A _1071_/D load_slew96/X VGND VGND VPWR VPWR _1071_/Q sky130_fd_sc_hd__dfrtp_2
X_0924_ _1082_/Q _1120_/Q VGND VGND VPWR VPWR _0928_/D sky130_fd_sc_hd__xnor2_2
X_0855_ hold259/X input2/X _0861_/S VGND VGND VPWR VPWR _1083_/D sky130_fd_sc_hd__mux2_1
X_0786_ _0786_/A _0786_/B VGND VGND VPWR VPWR _1228_/D sky130_fd_sc_hd__nor2_2
XFILLER_36_182 VGND VGND VPWR VPWR sky130_fd_sc_hd__decap_3
XFILLER_43_108 VGND VGND VPWR VPWR sky130_fd_sc_hd__decap_3
XFILLER_51_141 VGND VGND VPWR VPWR sky130_fd_sc_hd__decap_3
X_1269_ clkload6/A _1269_/D _1016_/B1 VGND VGND VPWR VPWR _1269_/Q sky130_fd_sc_hd__dfrtp_2
XPHY_EDGE_ROW_7_Left_59 VGND VGND VPWR VPWR sky130_fd_sc_hd__decap_3
XFILLER_10_75 VGND VGND VPWR VPWR sky130_fd_sc_hd__decap_3
XFILLER_15_300 VGND VGND VPWR VPWR sky130_fd_sc_hd__decap_3
XFILLER_19_51 VGND VGND VPWR VPWR sky130_fd_sc_hd__decap_3
XFILLER_27_193 VGND VGND VPWR VPWR sky130_fd_sc_hd__fill_2
XFILLER_42_141 VGND VGND VPWR VPWR sky130_fd_sc_hd__decap_3
XFILLER_42_174 VGND VGND VPWR VPWR sky130_fd_sc_hd__decap_3
XFILLER_51_60 VGND VGND VPWR VPWR sky130_fd_sc_hd__decap_3
X_0640_ hold157/X _1142_/Q _1253_/D _0639_/Y VGND VGND VPWR VPWR _0640_/Y sky130_fd_sc_hd__a211oi_2
X_0571_ _0774_/A VGND VGND VPWR VPWR _0778_/A sky130_fd_sc_hd__inv_2
XFILLER_18_193 VGND VGND VPWR VPWR sky130_fd_sc_hd__decap_3
XFILLER_21_303 VGND VGND VPWR VPWR sky130_fd_sc_hd__decap_3
X_1123_ _1212_/CLK _1123_/D fanout98/A VGND VGND VPWR VPWR _1123_/Q sky130_fd_sc_hd__dfrtp_2
X_1054_ _1067_/A1 _1067_/A2 _1055_/B1 VGND VGND VPWR VPWR _1054_/X sky130_fd_sc_hd__o21a_2
X_0907_ _1071_/Q input38/X _0917_/S VGND VGND VPWR VPWR _0907_/X sky130_fd_sc_hd__mux2_1
X_0838_ _0838_/A _0838_/B _0838_/C VGND VGND VPWR VPWR _1196_/D sky130_fd_sc_hd__or3_2
X_0769_ _1222_/Q _0770_/C _1223_/Q VGND VGND VPWR VPWR _0771_/B sky130_fd_sc_hd__a21oi_2
XFILLER_24_185 VGND VGND VPWR VPWR sky130_fd_sc_hd__decap_3
XFILLER_47_211 VGND VGND VPWR VPWR sky130_fd_sc_hd__decap_3
XFILLER_46_71 VGND VGND VPWR VPWR sky130_fd_sc_hd__decap_3
XFILLER_46_93 VGND VGND VPWR VPWR sky130_fd_sc_hd__decap_3
XFILLER_47_255 VGND VGND VPWR VPWR sky130_fd_sc_hd__decap_3
XFILLER_47_277 VGND VGND VPWR VPWR sky130_fd_sc_hd__decap_3
XFILLER_47_299 VGND VGND VPWR VPWR sky130_fd_sc_hd__decap_3
XFILLER_30_100 VGND VGND VPWR VPWR sky130_fd_sc_hd__decap_3
XFILLER_30_166 VGND VGND VPWR VPWR sky130_fd_sc_hd__decap_3
X_0623_ _0623_/A _0623_/B VGND VGND VPWR VPWR _1204_/D sky130_fd_sc_hd__xnor2_2
X_0554_ _1231_/Q VGND VGND VPWR VPWR _0554_/Y sky130_fd_sc_hd__inv_2
XFILLER_7_65 VGND VGND VPWR VPWR sky130_fd_sc_hd__decap_3
XFILLER_38_288 VGND VGND VPWR VPWR sky130_fd_sc_hd__decap_3
X_1106_ _1192_/CLK _1106_/D load_slew117/X VGND VGND VPWR VPWR _1106_/Q sky130_fd_sc_hd__dfrtp_2
XFILLER_21_100 VGND VGND VPWR VPWR sky130_fd_sc_hd__fill_2
X_1037_ _1042_/A1 _1042_/A2 _1042_/B1 VGND VGND VPWR VPWR _1037_/X sky130_fd_sc_hd__o21a_2
XTAP_TAPCELL_ROW_16_191 VGND VPWR sky130_fd_sc_hd__tapvpwrvgnd_1
XFILLER_21_177 VGND VGND VPWR VPWR sky130_fd_sc_hd__decap_3
XFILLER_16_52 VGND VGND VPWR VPWR sky130_fd_sc_hd__decap_3
XFILLER_29_255 VGND VGND VPWR VPWR sky130_fd_sc_hd__decap_3
XFILLER_44_258 VGND VGND VPWR VPWR sky130_fd_sc_hd__decap_3
XFILLER_12_144 VGND VGND VPWR VPWR sky130_fd_sc_hd__decap_3
XFILLER_12_177 VGND VGND VPWR VPWR sky130_fd_sc_hd__fill_1
XFILLER_16_85 VGND VGND VPWR VPWR sky130_fd_sc_hd__decap_3
XFILLER_32_40 VGND VGND VPWR VPWR sky130_fd_sc_hd__fill_1
XFILLER_32_62 VGND VGND VPWR VPWR sky130_fd_sc_hd__decap_3
XPHY_EDGE_ROW_11_Right_11 VGND VGND VPWR VPWR sky130_fd_sc_hd__decap_3
XPHY_EDGE_ROW_20_Right_20 VGND VGND VPWR VPWR sky130_fd_sc_hd__decap_3
XFILLER_50_206 VGND VGND VPWR VPWR sky130_fd_sc_hd__decap_3
XFILLER_50_239 VGND VGND VPWR VPWR sky130_fd_sc_hd__decap_3
XFILLER_7_192 VGND VGND VPWR VPWR sky130_fd_sc_hd__decap_3
Xhold137 _1259_/Q VGND VGND VPWR VPWR _1258_/D sky130_fd_sc_hd__dlygate4sd3_1
Xhold148 _1108_/Q VGND VGND VPWR VPWR _1173_/D sky130_fd_sc_hd__dlygate4sd3_1
Xhold159 _1103_/Q VGND VGND VPWR VPWR hold159/X sky130_fd_sc_hd__dlygate4sd3_1
X_0606_ _0648_/A _1257_/D _0605_/X VGND VGND VPWR VPWR _1129_/D sky130_fd_sc_hd__o21a_2
X_0537_ _1134_/Q VGND VGND VPWR VPWR _0537_/Y sky130_fd_sc_hd__inv_2
XFILLER_26_269 VGND VGND VPWR VPWR sky130_fd_sc_hd__decap_3
XFILLER_34_280 VGND VGND VPWR VPWR sky130_fd_sc_hd__fill_2
XFILLER_41_228 VGND VGND VPWR VPWR sky130_fd_sc_hd__decap_3
XPHY_EDGE_ROW_36_Left_88 VGND VGND VPWR VPWR sky130_fd_sc_hd__decap_3
XFILLER_17_225 VGND VGND VPWR VPWR sky130_fd_sc_hd__decap_3
XFILLER_17_269 VGND VGND VPWR VPWR sky130_fd_sc_hd__fill_1
XFILLER_40_250 VGND VGND VPWR VPWR sky130_fd_sc_hd__fill_2
XFILLER_43_72 VGND VGND VPWR VPWR sky130_fd_sc_hd__decap_3
XFILLER_4_195 VGND VGND VPWR VPWR sky130_fd_sc_hd__fill_1
XFILLER_16_280 VGND VGND VPWR VPWR sky130_fd_sc_hd__decap_3
XFILLER_23_217 VGND VGND VPWR VPWR sky130_fd_sc_hd__decap_3
XFILLER_23_228 VGND VGND VPWR VPWR sky130_fd_sc_hd__decap_3
XFILLER_31_261 VGND VGND VPWR VPWR sky130_fd_sc_hd__decap_3
XTAP_TAPCELL_ROW_33_278 VGND VPWR sky130_fd_sc_hd__tapvpwrvgnd_1
XFILLER_48_39 VGND VGND VPWR VPWR sky130_fd_sc_hd__fill_2
XFILLER_14_228 VGND VGND VPWR VPWR sky130_fd_sc_hd__decap_3
XFILLER_13_31 VGND VGND VPWR VPWR sky130_fd_sc_hd__decap_3
XFILLER_22_261 VGND VGND VPWR VPWR sky130_fd_sc_hd__decap_3
Xfanout65 _1038_/A1 VGND VGND VPWR VPWR _1019_/A1 sky130_fd_sc_hd__clkdlybuf4s25_1
Xfanout76 _1038_/A2 VGND VGND VPWR VPWR _1064_/A2 sky130_fd_sc_hd__clkdlybuf4s25_1
Xfanout87 _1253_/Q VGND VGND VPWR VPWR _0815_/A sky130_fd_sc_hd__clkdlybuf4s25_1
Xfanout98 fanout98/A VGND VGND VPWR VPWR fanout98/X sky130_fd_sc_hd__clkdlybuf4s25_1
XFILLER_1_132 VGND VGND VPWR VPWR sky130_fd_sc_hd__decap_3
XFILLER_38_61 VGND VGND VPWR VPWR sky130_fd_sc_hd__decap_3
XFILLER_49_169 VGND VGND VPWR VPWR sky130_fd_sc_hd__decap_3
XTAP_TAPCELL_ROW_47_348 VGND VPWR sky130_fd_sc_hd__tapvpwrvgnd_1
X_0940_ _1122_/Q _0940_/B VGND VGND VPWR VPWR _0941_/B sky130_fd_sc_hd__or2_2
XFILLER_9_221 VGND VGND VPWR VPWR sky130_fd_sc_hd__decap_3
Xclkbuf_leaf_8_i_clk clkload2/A VGND VGND VPWR VPWR clkload8/A sky130_fd_sc_hd__clkbuf_8
X_0871_ _1173_/Q _1108_/Q VGND VGND VPWR VPWR _0871_/X sky130_fd_sc_hd__and2b_2
XTAP_TAPCELL_ROW_30_259 VGND VPWR sky130_fd_sc_hd__tapvpwrvgnd_1
X_1285_ _1285_/A VGND VGND VPWR VPWR _1285_/X sky130_fd_sc_hd__buf_2
XFILLER_48_180 VGND VGND VPWR VPWR sky130_fd_sc_hd__decap_3
Xclkload7 clkload7/A VGND VGND VPWR VPWR clkload7/X sky130_fd_sc_hd__clkbuf_8
XTAP_TAPCELL_ROW_21_215 VGND VPWR sky130_fd_sc_hd__tapvpwrvgnd_1
XFILLER_24_85 VGND VGND VPWR VPWR sky130_fd_sc_hd__decap_3
XTAP_TAPCELL_ROW_44_329 VGND VPWR sky130_fd_sc_hd__tapvpwrvgnd_1
XPHY_EDGE_ROW_39_Left_91 VGND VGND VPWR VPWR sky130_fd_sc_hd__decap_3
XFILLER_45_161 VGND VGND VPWR VPWR sky130_fd_sc_hd__fill_2
X_1070_ clkload5/A _1070_/D load_slew96/X VGND VGND VPWR VPWR _1070_/Q sky130_fd_sc_hd__dfrtp_2
X_0923_ _1087_/Q _1125_/Q VGND VGND VPWR VPWR _0927_/B sky130_fd_sc_hd__xnor2_2
X_0854_ hold270/X input1/X _0861_/S VGND VGND VPWR VPWR _1082_/D sky130_fd_sc_hd__mux2_1
XPHY_EDGE_ROW_23_Left_75 VGND VGND VPWR VPWR sky130_fd_sc_hd__decap_3
X_0785_ _1228_/Q _1227_/Q _0780_/X _0774_/A VGND VGND VPWR VPWR _0786_/B sky130_fd_sc_hd__a31o_2
XPHY_EDGE_ROW_49_Right_49 VGND VGND VPWR VPWR sky130_fd_sc_hd__decap_3
XFILLER_29_19 VGND VGND VPWR VPWR sky130_fd_sc_hd__decap_3
X_1268_ _1268_/CLK _1268_/D load_slew108/X VGND VGND VPWR VPWR _1268_/Q sky130_fd_sc_hd__dfrtp_2
XFILLER_36_161 VGND VGND VPWR VPWR sky130_fd_sc_hd__decap_3
XFILLER_51_153 VGND VGND VPWR VPWR sky130_fd_sc_hd__decap_3
XFILLER_51_175 VGND VGND VPWR VPWR sky130_fd_sc_hd__decap_3
XFILLER_51_197 VGND VGND VPWR VPWR sky130_fd_sc_hd__decap_3
X_1199_ clkload8/A _1199_/D _1007_/X VGND VGND VPWR VPWR _1199_/Q sky130_fd_sc_hd__dfrtp_2
XFILLER_10_21 VGND VGND VPWR VPWR sky130_fd_sc_hd__decap_3
XFILLER_19_139 VGND VGND VPWR VPWR sky130_fd_sc_hd__fill_2
XFILLER_27_172 VGND VGND VPWR VPWR sky130_fd_sc_hd__decap_3
XFILLER_42_120 VGND VGND VPWR VPWR sky130_fd_sc_hd__decap_3
XFILLER_42_153 VGND VGND VPWR VPWR sky130_fd_sc_hd__decap_3
XFILLER_51_72 VGND VGND VPWR VPWR sky130_fd_sc_hd__decap_3
XTAP_TAPCELL_ROW_40_310 VGND VPWR sky130_fd_sc_hd__tapvpwrvgnd_1
X_0570_ _1262_/Q VGND VGND VPWR VPWR _0570_/Y sky130_fd_sc_hd__inv_2
Xclkbuf_leaf_11_i_clk clkload2/A VGND VGND VPWR VPWR _1240_/CLK sky130_fd_sc_hd__clkbuf_8
X_1122_ clkload3/A _1122_/D fanout98/A VGND VGND VPWR VPWR _1122_/Q sky130_fd_sc_hd__dfrtp_2
XFILLER_33_131 VGND VGND VPWR VPWR sky130_fd_sc_hd__fill_2
X_1053_ _1053_/A1 _1053_/A2 _1055_/B1 VGND VGND VPWR VPWR _1053_/X sky130_fd_sc_hd__o21a_2
X_0906_ hold203/X _0677_/Y _0903_/Y _0905_/X VGND VGND VPWR VPWR _1112_/D sky130_fd_sc_hd__a22o_2
X_0837_ _1275_/Q _1111_/Q _1113_/Q _1272_/Q _0836_/X VGND VGND VPWR VPWR _0838_/C
+ sky130_fd_sc_hd__a221o_2
X_0768_ _1222_/Q _0770_/C _0767_/Y VGND VGND VPWR VPWR _1222_/D sky130_fd_sc_hd__o21a_2
X_0699_ _0699_/A _0699_/B _0699_/C _0699_/D VGND VGND VPWR VPWR _1179_/D sky130_fd_sc_hd__or4_2
XFILLER_24_120 VGND VGND VPWR VPWR sky130_fd_sc_hd__decap_3
XFILLER_21_97 VGND VGND VPWR VPWR sky130_fd_sc_hd__decap_3
XFILLER_47_223 VGND VGND VPWR VPWR sky130_fd_sc_hd__fill_1
XFILLER_47_234 VGND VGND VPWR VPWR sky130_fd_sc_hd__decap_3
XFILLER_30_112 VGND VGND VPWR VPWR sky130_fd_sc_hd__fill_2
XFILLER_46_50 VGND VGND VPWR VPWR sky130_fd_sc_hd__decap_3
XFILLER_30_178 VGND VGND VPWR VPWR sky130_fd_sc_hd__decap_3
XFILLER_30_189 VGND VGND VPWR VPWR sky130_fd_sc_hd__fill_2
XFILLER_30_3 VGND VGND VPWR VPWR sky130_fd_sc_hd__decap_3
X_0622_ _1201_/D _0621_/Y _0623_/B VGND VGND VPWR VPWR _1203_/D sky130_fd_sc_hd__o21ai_2
X_0553_ _1198_/Q VGND VGND VPWR VPWR _0553_/Y sky130_fd_sc_hd__inv_2
XFILLER_7_99 VGND VGND VPWR VPWR sky130_fd_sc_hd__fill_2
XFILLER_38_256 VGND VGND VPWR VPWR sky130_fd_sc_hd__decap_3
X_1105_ _1119_/CLK _1105_/D VGND VGND VPWR VPWR _1105_/Q sky130_fd_sc_hd__dfxtp_2
X_1036_ _1036_/A1 _1036_/A2 _1036_/B1 VGND VGND VPWR VPWR _1036_/X sky130_fd_sc_hd__o21a_2
XTAP_TAPCELL_ROW_16_192 VGND VPWR sky130_fd_sc_hd__tapvpwrvgnd_1
XFILLER_21_189 VGND VGND VPWR VPWR sky130_fd_sc_hd__fill_1
XTAP_TAPCELL_ROW_8_149 VGND VPWR sky130_fd_sc_hd__tapvpwrvgnd_1
XPHY_EDGE_ROW_10_Left_62 VGND VGND VPWR VPWR sky130_fd_sc_hd__decap_3
XFILLER_16_64 VGND VGND VPWR VPWR sky130_fd_sc_hd__decap_3
XFILLER_16_97 VGND VGND VPWR VPWR sky130_fd_sc_hd__decap_3
XFILLER_32_96 VGND VGND VPWR VPWR sky130_fd_sc_hd__fill_2
XFILLER_8_116 VGND VGND VPWR VPWR sky130_fd_sc_hd__decap_3
XFILLER_50_218 VGND VGND VPWR VPWR sky130_fd_sc_hd__decap_3
XFILLER_7_160 VGND VGND VPWR VPWR sky130_fd_sc_hd__decap_3
XFILLER_7_182 VGND VGND VPWR VPWR sky130_fd_sc_hd__fill_2
Xhold138 _1176_/Q VGND VGND VPWR VPWR _1174_/D sky130_fd_sc_hd__dlygate4sd3_1
Xhold149 _1258_/Q VGND VGND VPWR VPWR _1257_/D sky130_fd_sc_hd__dlygate4sd3_1
X_0605_ _0648_/A _1258_/Q hold193/X VGND VGND VPWR VPWR _0605_/X sky130_fd_sc_hd__a21o_2
X_0536_ _1135_/Q VGND VGND VPWR VPWR _0536_/Y sky130_fd_sc_hd__inv_2
XFILLER_41_207 VGND VGND VPWR VPWR sky130_fd_sc_hd__decap_3
X_1019_ _1019_/A1 _1019_/A2 _1019_/B1 VGND VGND VPWR VPWR _1019_/X sky130_fd_sc_hd__o21a_2
XFILLER_5_108 VGND VGND VPWR VPWR sky130_fd_sc_hd__decap_3
XFILLER_1_303 VGND VGND VPWR VPWR sky130_fd_sc_hd__decap_3
XFILLER_17_237 VGND VGND VPWR VPWR sky130_fd_sc_hd__decap_3
XFILLER_27_52 VGND VGND VPWR VPWR sky130_fd_sc_hd__decap_3
XTAP_TAPCELL_ROW_4_130 VGND VPWR sky130_fd_sc_hd__tapvpwrvgnd_1
XFILLER_25_281 VGND VGND VPWR VPWR sky130_fd_sc_hd__decap_3
XFILLER_25_292 VGND VGND VPWR VPWR sky130_fd_sc_hd__decap_3
XFILLER_40_262 VGND VGND VPWR VPWR sky130_fd_sc_hd__decap_3
XFILLER_43_84 VGND VGND VPWR VPWR sky130_fd_sc_hd__decap_3
XFILLER_4_141 VGND VGND VPWR VPWR sky130_fd_sc_hd__decap_3
XFILLER_4_185 VGND VGND VPWR VPWR sky130_fd_sc_hd__decap_3
XFILLER_4_78 VGND VGND VPWR VPWR sky130_fd_sc_hd__decap_3
XFILLER_16_270 VGND VGND VPWR VPWR sky130_fd_sc_hd__decap_3
XFILLER_48_29 VGND VGND VPWR VPWR sky130_fd_sc_hd__decap_3
Xfanout66 fanout73/X VGND VGND VPWR VPWR _1038_/A1 sky130_fd_sc_hd__clkdlybuf4s25_1
Xfanout77 _1038_/A2 VGND VGND VPWR VPWR _1063_/A2 sky130_fd_sc_hd__clkdlybuf4s25_1
Xfanout88 _1232_/Q VGND VGND VPWR VPWR _0774_/A sky130_fd_sc_hd__clkdlybuf4s25_1
XFILLER_1_111 VGND VGND VPWR VPWR sky130_fd_sc_hd__fill_1
XFILLER_1_166 VGND VGND VPWR VPWR sky130_fd_sc_hd__fill_2
XFILLER_49_148 VGND VGND VPWR VPWR sky130_fd_sc_hd__decap_3
XFILLER_8_3 VGND VGND VPWR VPWR sky130_fd_sc_hd__decap_3
XFILLER_13_262 VGND VGND VPWR VPWR sky130_fd_sc_hd__decap_3
X_0870_ hold227/X _0869_/X _0862_/Y VGND VGND VPWR VPWR _1093_/D sky130_fd_sc_hd__o21a_2
XFILLER_9_266 VGND VGND VPWR VPWR sky130_fd_sc_hd__decap_3
X_1284_ _1284_/A VGND VGND VPWR VPWR _1284_/X sky130_fd_sc_hd__buf_2
XFILLER_48_192 VGND VGND VPWR VPWR sky130_fd_sc_hd__decap_3
XFILLER_51_302 VGND VGND VPWR VPWR sky130_fd_sc_hd__decap_3
Xclkload8 clkload8/A VGND VGND VPWR VPWR clkload8/Y sky130_fd_sc_hd__clkinv_2
X_0999_ _1042_/A1 _1042_/A2 _1040_/B1 VGND VGND VPWR VPWR _0999_/X sky130_fd_sc_hd__o21a_2
XTAP_TAPCELL_ROW_21_216 VGND VPWR sky130_fd_sc_hd__tapvpwrvgnd_1
XFILLER_24_42 VGND VGND VPWR VPWR sky130_fd_sc_hd__decap_3
XFILLER_24_97 VGND VGND VPWR VPWR sky130_fd_sc_hd__decap_3
XFILLER_40_96 VGND VGND VPWR VPWR sky130_fd_sc_hd__fill_2
XFILLER_6_269 VGND VGND VPWR VPWR sky130_fd_sc_hd__fill_1
XFILLER_1_35 VGND VGND VPWR VPWR sky130_fd_sc_hd__decap_3
XFILLER_45_195 VGND VGND VPWR VPWR sky130_fd_sc_hd__decap_3
X_0922_ _1084_/Q _1122_/Q VGND VGND VPWR VPWR _0928_/C sky130_fd_sc_hd__xnor2_2
X_0853_ _1081_/Q input24/X _0861_/S VGND VGND VPWR VPWR _1081_/D sky130_fd_sc_hd__mux2_1
X_0784_ _1227_/Q _0780_/X hold253/X VGND VGND VPWR VPWR _0786_/A sky130_fd_sc_hd__a21oi_2
XFILLER_24_302 VGND VGND VPWR VPWR sky130_fd_sc_hd__decap_3
XFILLER_28_107 VGND VGND VPWR VPWR sky130_fd_sc_hd__decap_3
X_1267_ _1268_/CLK _1267_/D fanout107/X VGND VGND VPWR VPWR _1267_/Q sky130_fd_sc_hd__dfrtp_2
Xinput1 i_byte_cnt_reg[0] VGND VGND VPWR VPWR input1/X sky130_fd_sc_hd__clkdlybuf4s25_1
X_1198_ _1212_/CLK _1198_/D _1020_/B1 VGND VGND VPWR VPWR _1198_/Q sky130_fd_sc_hd__dfrtp_2
XFILLER_36_173 VGND VGND VPWR VPWR sky130_fd_sc_hd__decap_3
XFILLER_51_165 VGND VGND VPWR VPWR sky130_fd_sc_hd__decap_3
XFILLER_51_187 VGND VGND VPWR VPWR sky130_fd_sc_hd__decap_3
XPHY_EDGE_ROW_40_Left_92 VGND VGND VPWR VPWR sky130_fd_sc_hd__decap_3
XFILLER_27_184 VGND VGND VPWR VPWR sky130_fd_sc_hd__fill_1
XFILLER_42_132 VGND VGND VPWR VPWR sky130_fd_sc_hd__decap_3
Xclkbuf_leaf_7_i_clk clkload1/A VGND VGND VPWR VPWR clkload7/A sky130_fd_sc_hd__clkbuf_8
XFILLER_42_165 VGND VGND VPWR VPWR sky130_fd_sc_hd__decap_3
XFILLER_42_187 VGND VGND VPWR VPWR sky130_fd_sc_hd__fill_1
XTAP_TAPCELL_ROW_40_311 VGND VPWR sky130_fd_sc_hd__tapvpwrvgnd_1
XFILLER_25_6 VGND VGND VPWR VPWR sky130_fd_sc_hd__decap_3
X_1121_ clkload3/A _1121_/D load_slew99/X VGND VGND VPWR VPWR _1121_/Q sky130_fd_sc_hd__dfrtp_2
X_1052_ _1053_/A1 _1053_/A2 _1055_/B1 VGND VGND VPWR VPWR _1052_/X sky130_fd_sc_hd__o21a_2
XFILLER_18_184 VGND VGND VPWR VPWR sky130_fd_sc_hd__fill_1
X_0905_ _1070_/Q input37/X _0917_/S VGND VGND VPWR VPWR _0905_/X sky130_fd_sc_hd__mux2_1
X_0836_ _1276_/Q _1116_/Q _1117_/Q _1271_/Q VGND VGND VPWR VPWR _0836_/X sky130_fd_sc_hd__a22o_2
X_0767_ _1222_/Q _0770_/C _0774_/A VGND VGND VPWR VPWR _0767_/Y sky130_fd_sc_hd__a21oi_2
X_0698_ _0686_/Y _0687_/X _0691_/X _0692_/Y _0693_/X VGND VGND VPWR VPWR _0699_/D
+ sky130_fd_sc_hd__a221o_2
XFILLER_24_132 VGND VGND VPWR VPWR sky130_fd_sc_hd__decap_3
XFILLER_12_305 VGND VGND VPWR VPWR sky130_fd_sc_hd__decap_3
XFILLER_24_176 VGND VGND VPWR VPWR sky130_fd_sc_hd__decap_3
XFILLER_47_202 VGND VGND VPWR VPWR sky130_fd_sc_hd__decap_3
XFILLER_47_246 VGND VGND VPWR VPWR sky130_fd_sc_hd__decap_3
XFILLER_15_165 VGND VGND VPWR VPWR sky130_fd_sc_hd__decap_3
XFILLER_15_187 VGND VGND VPWR VPWR sky130_fd_sc_hd__fill_1
X_0621_ _0621_/A _0621_/B VGND VGND VPWR VPWR _0621_/Y sky130_fd_sc_hd__nand2_2
X_0552_ _1155_/Q VGND VGND VPWR VPWR _0552_/Y sky130_fd_sc_hd__inv_2
XFILLER_38_268 VGND VGND VPWR VPWR sky130_fd_sc_hd__fill_1
XFILLER_46_290 VGND VGND VPWR VPWR sky130_fd_sc_hd__decap_3
X_1104_ _1119_/CLK _1104_/D VGND VGND VPWR VPWR _1104_/Q sky130_fd_sc_hd__dfxtp_2
X_1035_ _1036_/A1 _1036_/A2 _1036_/B1 VGND VGND VPWR VPWR _1035_/X sky130_fd_sc_hd__o21a_2
XTAP_TAPCELL_ROW_16_193 VGND VPWR sky130_fd_sc_hd__tapvpwrvgnd_1
X_0819_ hold206/X _0815_/C _0818_/Y VGND VGND VPWR VPWR _0819_/X sky130_fd_sc_hd__o21a_2
XFILLER_29_213 VGND VGND VPWR VPWR sky130_fd_sc_hd__fill_1
XFILLER_29_246 VGND VGND VPWR VPWR sky130_fd_sc_hd__decap_3
XFILLER_16_32 VGND VGND VPWR VPWR sky130_fd_sc_hd__decap_3
Xclkbuf_leaf_10_i_clk clkload2/A VGND VGND VPWR VPWR clkload9/A sky130_fd_sc_hd__clkbuf_8
XTAP_TAPCELL_ROW_13_174 VGND VPWR sky130_fd_sc_hd__tapvpwrvgnd_1
Xhold139 _1183_/Q VGND VGND VPWR VPWR _1178_/D sky130_fd_sc_hd__dlygate4sd3_1
X_0604_ _0612_/A _1254_/D _0603_/X VGND VGND VPWR VPWR _1130_/D sky130_fd_sc_hd__o21a_2
XPHY_EDGE_ROW_9_Right_9 VGND VGND VPWR VPWR sky130_fd_sc_hd__decap_3
X_0535_ _1136_/Q VGND VGND VPWR VPWR _0535_/Y sky130_fd_sc_hd__inv_2
XFILLER_26_227 VGND VGND VPWR VPWR sky130_fd_sc_hd__decap_3
XFILLER_41_219 VGND VGND VPWR VPWR sky130_fd_sc_hd__decap_3
X_1018_ _1019_/A1 _1019_/A2 _1067_/B1 VGND VGND VPWR VPWR _1018_/X sky130_fd_sc_hd__o21a_2
XTAP_TAPCELL_ROW_4_131 VGND VPWR sky130_fd_sc_hd__tapvpwrvgnd_1
XFILLER_32_219 VGND VGND VPWR VPWR sky130_fd_sc_hd__decap_3
XFILLER_40_230 VGND VGND VPWR VPWR sky130_fd_sc_hd__decap_3
XFILLER_40_285 VGND VGND VPWR VPWR sky130_fd_sc_hd__decap_3
XFILLER_43_41 VGND VGND VPWR VPWR sky130_fd_sc_hd__decap_3
XFILLER_43_63 VGND VGND VPWR VPWR sky130_fd_sc_hd__decap_3
XFILLER_43_96 VGND VGND VPWR VPWR sky130_fd_sc_hd__decap_3
XTAP_TAPCELL_ROW_27_244 VGND VPWR sky130_fd_sc_hd__tapvpwrvgnd_1
XFILLER_4_120 VGND VGND VPWR VPWR sky130_fd_sc_hd__decap_3
XFILLER_23_208 VGND VGND VPWR VPWR sky130_fd_sc_hd__decap_3
XTAP_TAPCELL_ROW_18_200 VGND VPWR sky130_fd_sc_hd__tapvpwrvgnd_1
XFILLER_31_252 VGND VGND VPWR VPWR sky130_fd_sc_hd__decap_3
XFILLER_14_219 VGND VGND VPWR VPWR sky130_fd_sc_hd__decap_3
Xfanout67 fanout73/X VGND VGND VPWR VPWR _1036_/A1 sky130_fd_sc_hd__clkdlybuf4s25_1
Xfanout78 _1038_/A2 VGND VGND VPWR VPWR _1019_/A2 sky130_fd_sc_hd__clkdlybuf4s25_1
Xfanout89 _0970_/S VGND VGND VPWR VPWR _0974_/S sky130_fd_sc_hd__clkdlybuf4s25_1
XFILLER_1_123 VGND VGND VPWR VPWR sky130_fd_sc_hd__fill_1
XFILLER_49_105 VGND VGND VPWR VPWR sky130_fd_sc_hd__decap_3
XFILLER_38_85 VGND VGND VPWR VPWR sky130_fd_sc_hd__decap_3
XFILLER_45_300 VGND VGND VPWR VPWR sky130_fd_sc_hd__decap_3
XFILLER_9_234 VGND VGND VPWR VPWR sky130_fd_sc_hd__fill_1
XFILLER_48_171 VGND VGND VPWR VPWR sky130_fd_sc_hd__decap_3
X_1283_ _1283_/A VGND VGND VPWR VPWR _1283_/X sky130_fd_sc_hd__buf_2
XTAP_TAPCELL_ROW_21_217 VGND VPWR sky130_fd_sc_hd__tapvpwrvgnd_1
Xclkload9 clkload9/A VGND VGND VPWR VPWR clkload9/Y sky130_fd_sc_hd__clkinv_2
X_0998_ _1038_/A1 _1038_/A2 _1040_/B1 VGND VGND VPWR VPWR _0998_/X sky130_fd_sc_hd__o21a_2
XFILLER_10_266 VGND VGND VPWR VPWR sky130_fd_sc_hd__fill_2
XFILLER_24_32 VGND VGND VPWR VPWR sky130_fd_sc_hd__decap_3
XFILLER_24_54 VGND VGND VPWR VPWR sky130_fd_sc_hd__decap_3
XFILLER_6_204 VGND VGND VPWR VPWR sky130_fd_sc_hd__decap_3
XFILLER_40_64 VGND VGND VPWR VPWR sky130_fd_sc_hd__decap_3
XFILLER_49_73 VGND VGND VPWR VPWR sky130_fd_sc_hd__decap_3
XFILLER_45_152 VGND VGND VPWR VPWR sky130_fd_sc_hd__decap_3
X_0921_ _1085_/Q _1123_/Q VGND VGND VPWR VPWR _0927_/A sky130_fd_sc_hd__xnor2_2
X_0852_ _1080_/Q input25/X _0860_/S VGND VGND VPWR VPWR _1080_/D sky130_fd_sc_hd__mux2_1
X_0783_ _1227_/Q _0780_/X _0782_/Y VGND VGND VPWR VPWR _1227_/D sky130_fd_sc_hd__o21a_2
XFILLER_5_281 VGND VGND VPWR VPWR sky130_fd_sc_hd__decap_3
XFILLER_36_141 VGND VGND VPWR VPWR sky130_fd_sc_hd__decap_3
XFILLER_36_185 VGND VGND VPWR VPWR sky130_fd_sc_hd__decap_3
XFILLER_51_100 VGND VGND VPWR VPWR sky130_fd_sc_hd__decap_3
X_1266_ _1268_/CLK _1266_/D _1064_/B1 VGND VGND VPWR VPWR _1266_/Q sky130_fd_sc_hd__dfrtp_2
Xinput2 i_byte_cnt_reg[1] VGND VGND VPWR VPWR input2/X sky130_fd_sc_hd__clkdlybuf4s25_1
X_1197_ clkload4/A _1197_/D fanout105/X VGND VGND VPWR VPWR _1197_/Q sky130_fd_sc_hd__dfrtp_2
XFILLER_51_122 VGND VGND VPWR VPWR sky130_fd_sc_hd__decap_3
XFILLER_51_144 VGND VGND VPWR VPWR sky130_fd_sc_hd__decap_3
XFILLER_10_12 VGND VGND VPWR VPWR sky130_fd_sc_hd__decap_3
XFILLER_10_78 VGND VGND VPWR VPWR sky130_fd_sc_hd__decap_3
XFILLER_19_54 VGND VGND VPWR VPWR sky130_fd_sc_hd__fill_2
XFILLER_15_303 VGND VGND VPWR VPWR sky130_fd_sc_hd__decap_3
XFILLER_42_111 VGND VGND VPWR VPWR sky130_fd_sc_hd__decap_3
XFILLER_42_144 VGND VGND VPWR VPWR sky130_fd_sc_hd__decap_3
XFILLER_42_177 VGND VGND VPWR VPWR sky130_fd_sc_hd__decap_3
XFILLER_51_52 VGND VGND VPWR VPWR sky130_fd_sc_hd__decap_3
XFILLER_51_63 VGND VGND VPWR VPWR sky130_fd_sc_hd__decap_3
XTAP_TAPCELL_ROW_40_312 VGND VPWR sky130_fd_sc_hd__tapvpwrvgnd_1
XFILLER_2_251 VGND VGND VPWR VPWR sky130_fd_sc_hd__fill_1
X_1120_ _1212_/CLK _1120_/D fanout98/X VGND VGND VPWR VPWR _1120_/Q sky130_fd_sc_hd__dfrtp_2
X_1051_ _1053_/A1 _1053_/A2 _1055_/B1 VGND VGND VPWR VPWR _1051_/X sky130_fd_sc_hd__o21a_2
XFILLER_21_306 VGND VGND VPWR VPWR sky130_fd_sc_hd__fill_2
XFILLER_33_177 VGND VGND VPWR VPWR sky130_fd_sc_hd__fill_1
X_0904_ _1161_/Q _1080_/Q _0677_/Y VGND VGND VPWR VPWR _0904_/X sky130_fd_sc_hd__a21o_2
X_0835_ _1277_/Q _1112_/Q _1118_/Q _1170_/Q _0834_/X VGND VGND VPWR VPWR _0838_/B
+ sky130_fd_sc_hd__a221o_2
X_0766_ _0774_/A _0766_/B _0770_/C VGND VGND VPWR VPWR _1221_/D sky130_fd_sc_hd__nor3_2
X_0697_ _0688_/X _0689_/Y _0694_/X _0695_/Y VGND VGND VPWR VPWR _0699_/C sky130_fd_sc_hd__a22o_2
XFILLER_24_100 VGND VGND VPWR VPWR sky130_fd_sc_hd__fill_2
XFILLER_24_111 VGND VGND VPWR VPWR sky130_fd_sc_hd__decap_3
X_1249_ _1259_/CLK _1249_/D _1057_/X VGND VGND VPWR VPWR _1249_/Q sky130_fd_sc_hd__dfrtp_2
XFILLER_21_33 VGND VGND VPWR VPWR sky130_fd_sc_hd__fill_1
XFILLER_21_55 VGND VGND VPWR VPWR sky130_fd_sc_hd__fill_1
XFILLER_24_188 VGND VGND VPWR VPWR sky130_fd_sc_hd__fill_2
XFILLER_15_100 VGND VGND VPWR VPWR sky130_fd_sc_hd__decap_3
XFILLER_46_74 VGND VGND VPWR VPWR sky130_fd_sc_hd__fill_1
XFILLER_46_85 VGND VGND VPWR VPWR sky130_fd_sc_hd__fill_1
XFILLER_47_214 VGND VGND VPWR VPWR sky130_fd_sc_hd__decap_3
XFILLER_47_225 VGND VGND VPWR VPWR sky130_fd_sc_hd__decap_3
XFILLER_47_258 VGND VGND VPWR VPWR sky130_fd_sc_hd__decap_3
XFILLER_30_103 VGND VGND VPWR VPWR sky130_fd_sc_hd__decap_3
XFILLER_30_169 VGND VGND VPWR VPWR sky130_fd_sc_hd__decap_3
X_0620_ input9/X _0621_/A _0621_/B VGND VGND VPWR VPWR _0623_/B sky130_fd_sc_hd__a21o_2
X_0551_ _1188_/Q VGND VGND VPWR VPWR _0551_/Y sky130_fd_sc_hd__inv_2
XFILLER_7_68 VGND VGND VPWR VPWR sky130_fd_sc_hd__fill_1
XFILLER_16_3 VGND VGND VPWR VPWR sky130_fd_sc_hd__decap_3
X_1103_ _1119_/CLK _1103_/D VGND VGND VPWR VPWR _1103_/Q sky130_fd_sc_hd__dfxtp_2
X_1034_ _1036_/A1 _1036_/A2 _1034_/B1 VGND VGND VPWR VPWR _1034_/X sky130_fd_sc_hd__o21a_2
XFILLER_21_169 VGND VGND VPWR VPWR sky130_fd_sc_hd__fill_1
Xclkbuf_leaf_6_i_clk clkload1/A VGND VGND VPWR VPWR _1211_/CLK sky130_fd_sc_hd__clkbuf_8
X_0818_ _1253_/Q _0821_/B VGND VGND VPWR VPWR _0818_/Y sky130_fd_sc_hd__nor2_2
X_0749_ _0558_/Y _0747_/C _0748_/X VGND VGND VPWR VPWR _1215_/D sky130_fd_sc_hd__a21oi_2
XFILLER_29_225 VGND VGND VPWR VPWR sky130_fd_sc_hd__decap_3
XFILLER_29_258 VGND VGND VPWR VPWR sky130_fd_sc_hd__decap_3
XFILLER_12_147 VGND VGND VPWR VPWR sky130_fd_sc_hd__decap_3
XFILLER_16_55 VGND VGND VPWR VPWR sky130_fd_sc_hd__decap_3
XFILLER_16_88 VGND VGND VPWR VPWR sky130_fd_sc_hd__decap_3
XFILLER_8_107 VGND VGND VPWR VPWR sky130_fd_sc_hd__decap_3
XFILLER_50_209 VGND VGND VPWR VPWR sky130_fd_sc_hd__decap_3
XTAP_TAPCELL_ROW_13_175 VGND VPWR sky130_fd_sc_hd__tapvpwrvgnd_1
X_0603_ _1130_/Q _1255_/Q hold186/X VGND VGND VPWR VPWR _0603_/X sky130_fd_sc_hd__a21o_2
X_0534_ _1137_/Q VGND VGND VPWR VPWR _0534_/Y sky130_fd_sc_hd__inv_2
XFILLER_7_195 VGND VGND VPWR VPWR sky130_fd_sc_hd__fill_1
X_1017_ _1017_/A1 _1017_/A2 _1017_/B1 VGND VGND VPWR VPWR _1017_/X sky130_fd_sc_hd__o21a_2
XTAP_TAPCELL_ROW_36_289 VGND VPWR sky130_fd_sc_hd__tapvpwrvgnd_1
XTAP_TAPCELL_ROW_4_132 VGND VPWR sky130_fd_sc_hd__tapvpwrvgnd_1
XFILLER_17_228 VGND VGND VPWR VPWR sky130_fd_sc_hd__decap_3
XTAP_TAPCELL_ROW_27_245 VGND VPWR sky130_fd_sc_hd__tapvpwrvgnd_1
XFILLER_40_253 VGND VGND VPWR VPWR sky130_fd_sc_hd__decap_3
XFILLER_43_75 VGND VGND VPWR VPWR sky130_fd_sc_hd__decap_3
XFILLER_4_25 VGND VGND VPWR VPWR sky130_fd_sc_hd__decap_3
XFILLER_4_69 VGND VGND VPWR VPWR sky130_fd_sc_hd__fill_1
XFILLER_16_283 VGND VGND VPWR VPWR sky130_fd_sc_hd__decap_3
XTAP_TAPCELL_ROW_18_201 VGND VPWR sky130_fd_sc_hd__tapvpwrvgnd_1
XFILLER_31_264 VGND VGND VPWR VPWR sky130_fd_sc_hd__decap_3
XFILLER_31_275 VGND VGND VPWR VPWR sky130_fd_sc_hd__decap_3
XFILLER_13_34 VGND VGND VPWR VPWR sky130_fd_sc_hd__fill_1
XFILLER_22_264 VGND VGND VPWR VPWR sky130_fd_sc_hd__fill_1
Xfanout68 fanout73/X VGND VGND VPWR VPWR _1027_/A1 sky130_fd_sc_hd__clkdlybuf4s25_1
Xfanout79 fanout86/X VGND VGND VPWR VPWR _1038_/A2 sky130_fd_sc_hd__clkdlybuf4s25_1
XTAP_TAPCELL_ROW_32_270 VGND VPWR sky130_fd_sc_hd__tapvpwrvgnd_1
XFILLER_1_113 VGND VGND VPWR VPWR sky130_fd_sc_hd__fill_1
XFILLER_1_135 VGND VGND VPWR VPWR sky130_fd_sc_hd__fill_2
XFILLER_38_64 VGND VGND VPWR VPWR sky130_fd_sc_hd__decap_3
XFILLER_13_231 VGND VGND VPWR VPWR sky130_fd_sc_hd__decap_3
XFILLER_13_275 VGND VGND VPWR VPWR sky130_fd_sc_hd__decap_3
XFILLER_36_301 VGND VGND VPWR VPWR sky130_fd_sc_hd__decap_3
XFILLER_48_150 VGND VGND VPWR VPWR sky130_fd_sc_hd__decap_3
XFILLER_48_183 VGND VGND VPWR VPWR sky130_fd_sc_hd__decap_3
XTAP_TAPCELL_ROW_46_340 VGND VPWR sky130_fd_sc_hd__tapvpwrvgnd_1
XTAP_TAPCELL_ROW_21_218 VGND VPWR sky130_fd_sc_hd__tapvpwrvgnd_1
X_0997_ _1042_/A1 _1042_/A2 _1040_/B1 VGND VGND VPWR VPWR _0997_/X sky130_fd_sc_hd__o21a_2
XFILLER_27_301 VGND VGND VPWR VPWR sky130_fd_sc_hd__decap_3
XFILLER_24_88 VGND VGND VPWR VPWR sky130_fd_sc_hd__decap_3
XFILLER_37_109 VGND VGND VPWR VPWR sky130_fd_sc_hd__decap_3
XFILLER_45_142 VGND VGND VPWR VPWR sky130_fd_sc_hd__fill_2
XFILLER_45_186 VGND VGND VPWR VPWR sky130_fd_sc_hd__decap_3
X_0920_ _1088_/Q _1126_/Q VGND VGND VPWR VPWR _0928_/B sky130_fd_sc_hd__xnor2_2
X_0851_ _0569_/A input27/X _0874_/S VGND VGND VPWR VPWR _1079_/D sky130_fd_sc_hd__mux2_1
X_0782_ _1227_/Q _0780_/X _0774_/A VGND VGND VPWR VPWR _0782_/Y sky130_fd_sc_hd__a21oi_2
X_1265_ clkload6/A _1265_/D load_slew108/X VGND VGND VPWR VPWR _1265_/Q sky130_fd_sc_hd__dfrtp_2
XPHY_EDGE_ROW_18_Right_18 VGND VGND VPWR VPWR sky130_fd_sc_hd__decap_3
XFILLER_36_164 VGND VGND VPWR VPWR sky130_fd_sc_hd__decap_3
XFILLER_51_134 VGND VGND VPWR VPWR sky130_fd_sc_hd__decap_3
Xinput3 i_byte_cnt_reg[2] VGND VGND VPWR VPWR input3/X sky130_fd_sc_hd__clkdlybuf4s25_1
X_1196_ _1268_/CLK _1196_/D _1064_/B1 VGND VGND VPWR VPWR _1196_/Q sky130_fd_sc_hd__dfstp_2
XPHY_EDGE_ROW_27_Right_27 VGND VGND VPWR VPWR sky130_fd_sc_hd__decap_3
XFILLER_51_156 VGND VGND VPWR VPWR sky130_fd_sc_hd__decap_3
XFILLER_51_178 VGND VGND VPWR VPWR sky130_fd_sc_hd__decap_3
XFILLER_10_24 VGND VGND VPWR VPWR sky130_fd_sc_hd__decap_3
XPHY_EDGE_ROW_36_Right_36 VGND VGND VPWR VPWR sky130_fd_sc_hd__decap_3
XFILLER_19_22 VGND VGND VPWR VPWR sky130_fd_sc_hd__fill_1
XFILLER_27_175 VGND VGND VPWR VPWR sky130_fd_sc_hd__fill_1
XFILLER_35_32 VGND VGND VPWR VPWR sky130_fd_sc_hd__decap_3
XFILLER_42_123 VGND VGND VPWR VPWR sky130_fd_sc_hd__decap_3
XFILLER_42_156 VGND VGND VPWR VPWR sky130_fd_sc_hd__decap_3
XFILLER_51_20 VGND VGND VPWR VPWR sky130_fd_sc_hd__decap_3
XTAP_TAPCELL_ROW_40_313 VGND VPWR sky130_fd_sc_hd__tapvpwrvgnd_1
XPHY_EDGE_ROW_45_Right_45 VGND VGND VPWR VPWR sky130_fd_sc_hd__decap_3
XFILLER_51_75 VGND VGND VPWR VPWR sky130_fd_sc_hd__decap_3
XFILLER_51_97 VGND VGND VPWR VPWR sky130_fd_sc_hd__decap_3
XPHY_EDGE_ROW_27_Left_79 VGND VGND VPWR VPWR sky130_fd_sc_hd__decap_3
X_1050_ _1053_/A1 _1053_/A2 _1055_/B1 VGND VGND VPWR VPWR _1050_/X sky130_fd_sc_hd__o21a_2
X_0903_ _1161_/Q _1080_/Q _0677_/Y VGND VGND VPWR VPWR _0903_/Y sky130_fd_sc_hd__a21oi_2
X_0834_ _1278_/Q _1114_/Q _1115_/Q _1273_/Q VGND VGND VPWR VPWR _0834_/X sky130_fd_sc_hd__a22o_2
X_0765_ _1221_/Q _0780_/A _0780_/B VGND VGND VPWR VPWR _0770_/C sky130_fd_sc_hd__and3_2
X_0696_ _0696_/A _1074_/Q VGND VGND VPWR VPWR _0699_/B sky130_fd_sc_hd__xor2_2
X_1248_ clkload9/A _1248_/D _1056_/X VGND VGND VPWR VPWR _1248_/Q sky130_fd_sc_hd__dfrtp_2
XFILLER_24_123 VGND VGND VPWR VPWR sky130_fd_sc_hd__decap_3
X_1179_ _1191_/CLK _1179_/D fanout116/X VGND VGND VPWR VPWR _1179_/Q sky130_fd_sc_hd__dfrtp_2
XFILLER_46_53 VGND VGND VPWR VPWR sky130_fd_sc_hd__decap_3
XFILLER_47_237 VGND VGND VPWR VPWR sky130_fd_sc_hd__decap_3
X_0550_ _1194_/Q VGND VGND VPWR VPWR _0550_/Y sky130_fd_sc_hd__inv_2
XFILLER_30_6 VGND VGND VPWR VPWR sky130_fd_sc_hd__decap_3
XFILLER_38_259 VGND VGND VPWR VPWR sky130_fd_sc_hd__decap_3
X_1102_ _1119_/CLK _1102_/D VGND VGND VPWR VPWR _1102_/Q sky130_fd_sc_hd__dfxtp_2
X_1033_ _1036_/A1 _1036_/A2 _1034_/B1 VGND VGND VPWR VPWR _1033_/X sky130_fd_sc_hd__o21a_2
X_0817_ _0824_/A _0824_/B _0824_/C VGND VGND VPWR VPWR _0821_/B sky130_fd_sc_hd__and3_2
X_0748_ _1214_/Q _1213_/Q _1215_/Q _0774_/A VGND VGND VPWR VPWR _0748_/X sky130_fd_sc_hd__a31o_2
X_0679_ _1197_/Q _0678_/X _1191_/D VGND VGND VPWR VPWR _0680_/B sky130_fd_sc_hd__a21oi_2
XFILLER_12_115 VGND VGND VPWR VPWR sky130_fd_sc_hd__decap_3
XFILLER_16_67 VGND VGND VPWR VPWR sky130_fd_sc_hd__decap_3
XPHY_EDGE_ROW_0_Right_0 VGND VGND VPWR VPWR sky130_fd_sc_hd__decap_3
XFILLER_8_119 VGND VGND VPWR VPWR sky130_fd_sc_hd__fill_2
XFILLER_43_295 VGND VGND VPWR VPWR sky130_fd_sc_hd__decap_3
XFILLER_7_163 VGND VGND VPWR VPWR sky130_fd_sc_hd__decap_3
XTAP_TAPCELL_ROW_13_176 VGND VPWR sky130_fd_sc_hd__tapvpwrvgnd_1
X_0602_ hold178/X _1131_/Q _0601_/Y VGND VGND VPWR VPWR _0602_/Y sky130_fd_sc_hd__a21oi_2
X_0533_ _1128_/Q VGND VGND VPWR VPWR _0930_/A sky130_fd_sc_hd__inv_2
XFILLER_34_251 VGND VGND VPWR VPWR sky130_fd_sc_hd__fill_1
XFILLER_34_262 VGND VGND VPWR VPWR sky130_fd_sc_hd__fill_2
X_1016_ _1017_/A1 _1017_/A2 _1016_/B1 VGND VGND VPWR VPWR _1016_/X sky130_fd_sc_hd__o21a_2
XPHY_EDGE_ROW_14_Left_66 VGND VGND VPWR VPWR sky130_fd_sc_hd__decap_3
XFILLER_1_306 VGND VGND VPWR VPWR sky130_fd_sc_hd__fill_2
XTAP_TAPCELL_ROW_4_133 VGND VPWR sky130_fd_sc_hd__tapvpwrvgnd_1
XFILLER_25_262 VGND VGND VPWR VPWR sky130_fd_sc_hd__decap_3
XFILLER_25_284 VGND VGND VPWR VPWR sky130_fd_sc_hd__fill_1
XFILLER_27_55 VGND VGND VPWR VPWR sky130_fd_sc_hd__fill_1
XFILLER_43_32 VGND VGND VPWR VPWR sky130_fd_sc_hd__decap_3
XTAP_TAPCELL_ROW_27_246 VGND VPWR sky130_fd_sc_hd__tapvpwrvgnd_1
XFILLER_25_295 VGND VGND VPWR VPWR sky130_fd_sc_hd__decap_3
XFILLER_40_221 VGND VGND VPWR VPWR sky130_fd_sc_hd__decap_3
XFILLER_40_265 VGND VGND VPWR VPWR sky130_fd_sc_hd__decap_3
XFILLER_43_54 VGND VGND VPWR VPWR sky130_fd_sc_hd__fill_2
XFILLER_43_87 VGND VGND VPWR VPWR sky130_fd_sc_hd__decap_3
XFILLER_4_144 VGND VGND VPWR VPWR sky130_fd_sc_hd__decap_3
Xclkbuf_leaf_5_i_clk clkload1/A VGND VGND VPWR VPWR clkload6/A sky130_fd_sc_hd__clkbuf_8
XTAP_TAPCELL_ROW_18_202 VGND VPWR sky130_fd_sc_hd__tapvpwrvgnd_1
XFILLER_31_221 VGND VGND VPWR VPWR sky130_fd_sc_hd__decap_3
XTAP_TAPCELL_ROW_1_114 VGND VPWR sky130_fd_sc_hd__tapvpwrvgnd_1
XFILLER_13_57 VGND VGND VPWR VPWR sky130_fd_sc_hd__decap_3
XFILLER_22_232 VGND VGND VPWR VPWR sky130_fd_sc_hd__fill_2
Xfanout69 fanout73/X VGND VGND VPWR VPWR _1042_/A1 sky130_fd_sc_hd__clkdlybuf4s25_1
XTAP_TAPCELL_ROW_32_271 VGND VPWR sky130_fd_sc_hd__tapvpwrvgnd_1
XFILLER_8_6 VGND VGND VPWR VPWR sky130_fd_sc_hd__decap_3
XFILLER_1_169 VGND VGND VPWR VPWR sky130_fd_sc_hd__fill_2
XFILLER_13_265 VGND VGND VPWR VPWR sky130_fd_sc_hd__decap_3
XFILLER_9_225 VGND VGND VPWR VPWR sky130_fd_sc_hd__decap_3
XFILLER_9_269 VGND VGND VPWR VPWR sky130_fd_sc_hd__decap_3
XFILLER_48_162 VGND VGND VPWR VPWR sky130_fd_sc_hd__decap_3
XFILLER_48_195 VGND VGND VPWR VPWR sky130_fd_sc_hd__fill_1
XFILLER_51_305 VGND VGND VPWR VPWR sky130_fd_sc_hd__decap_3
XTAP_TAPCELL_ROW_46_341 VGND VPWR sky130_fd_sc_hd__tapvpwrvgnd_1
X_0996_ _1038_/A1 _1038_/A2 _1064_/B1 VGND VGND VPWR VPWR _0996_/X sky130_fd_sc_hd__o21a_2
XFILLER_5_91 VGND VGND VPWR VPWR sky130_fd_sc_hd__fill_2
XFILLER_24_45 VGND VGND VPWR VPWR sky130_fd_sc_hd__decap_3
Xhold280 _1074_/Q VGND VGND VPWR VPWR hold280/X sky130_fd_sc_hd__dlygate4sd3_1
XFILLER_1_38 VGND VGND VPWR VPWR sky130_fd_sc_hd__fill_1
XFILLER_45_198 VGND VGND VPWR VPWR sky130_fd_sc_hd__decap_3
X_0850_ _0730_/B input26/X _0874_/S VGND VGND VPWR VPWR _1078_/D sky130_fd_sc_hd__mux2_1
X_0781_ _0562_/Y _0778_/C _0780_/X _0774_/A VGND VGND VPWR VPWR _1226_/D sky130_fd_sc_hd__a211oi_2
XFILLER_39_3 VGND VGND VPWR VPWR sky130_fd_sc_hd__decap_3
X_1264_ clkload6/A _1264_/D load_slew108/X VGND VGND VPWR VPWR _1264_/Q sky130_fd_sc_hd__dfrtp_2
Xinput4 i_byte_cnt_reg[3] VGND VGND VPWR VPWR input4/X sky130_fd_sc_hd__clkdlybuf4s25_1
XFILLER_24_305 VGND VGND VPWR VPWR sky130_fd_sc_hd__decap_3
XFILLER_36_176 VGND VGND VPWR VPWR sky130_fd_sc_hd__decap_3
XFILLER_51_113 VGND VGND VPWR VPWR sky130_fd_sc_hd__decap_3
X_1195_ _1212_/CLK _1195_/D _1020_/B1 VGND VGND VPWR VPWR _1195_/Q sky130_fd_sc_hd__dfrtp_2
X_0979_ _1064_/A1 _1064_/A2 _1064_/B1 VGND VGND VPWR VPWR _0979_/X sky130_fd_sc_hd__o21a_2
XFILLER_42_102 VGND VGND VPWR VPWR sky130_fd_sc_hd__decap_3
XFILLER_42_135 VGND VGND VPWR VPWR sky130_fd_sc_hd__decap_3
XFILLER_42_168 VGND VGND VPWR VPWR sky130_fd_sc_hd__decap_3
XPHY_EDGE_ROW_2_Left_54 VGND VGND VPWR VPWR sky130_fd_sc_hd__decap_3
XFILLER_18_110 VGND VGND VPWR VPWR sky130_fd_sc_hd__fill_2
X_0902_ hold190/X _0678_/X _0901_/X VGND VGND VPWR VPWR _1111_/D sky130_fd_sc_hd__o21a_2
X_0833_ _0833_/A _0833_/B VGND VGND VPWR VPWR _0838_/A sky130_fd_sc_hd__nor2_2
X_0764_ _0780_/A _0780_/B _1221_/Q VGND VGND VPWR VPWR _0766_/B sky130_fd_sc_hd__a21oi_2
X_0695_ _0695_/A _1075_/Q VGND VGND VPWR VPWR _0695_/Y sky130_fd_sc_hd__nand2_2
XFILLER_49_290 VGND VGND VPWR VPWR sky130_fd_sc_hd__decap_3
X_1247_ clkload9/A _1247_/D _1055_/X VGND VGND VPWR VPWR _1247_/Q sky130_fd_sc_hd__dfrtp_2
X_1178_ _1262_/CLK _1178_/D _1036_/B1 VGND VGND VPWR VPWR _1178_/Q sky130_fd_sc_hd__dfrtp_2
XFILLER_24_135 VGND VGND VPWR VPWR sky130_fd_sc_hd__fill_2
XFILLER_24_146 VGND VGND VPWR VPWR sky130_fd_sc_hd__fill_2
XFILLER_24_179 VGND VGND VPWR VPWR sky130_fd_sc_hd__decap_3
XPHY_EDGE_ROW_44_Left_96 VGND VGND VPWR VPWR sky130_fd_sc_hd__decap_3
XFILLER_21_57 VGND VGND VPWR VPWR sky130_fd_sc_hd__decap_3
XFILLER_21_68 VGND VGND VPWR VPWR sky130_fd_sc_hd__fill_2
XFILLER_47_205 VGND VGND VPWR VPWR sky130_fd_sc_hd__decap_3
XFILLER_15_157 VGND VGND VPWR VPWR sky130_fd_sc_hd__fill_1
XFILLER_47_249 VGND VGND VPWR VPWR sky130_fd_sc_hd__decap_3
X_1101_ clkload6/A _1101_/D VGND VGND VPWR VPWR _1101_/Q sky130_fd_sc_hd__dfxtp_2
X_1032_ _1036_/A1 _1036_/A2 _1036_/B1 VGND VGND VPWR VPWR _1032_/X sky130_fd_sc_hd__o21a_2
XFILLER_46_293 VGND VGND VPWR VPWR sky130_fd_sc_hd__decap_3
Xinput40 i_transmit_data[4] VGND VGND VPWR VPWR input40/X sky130_fd_sc_hd__clkdlybuf4s25_1
X_0816_ _1244_/Q _1243_/Q _1246_/Q _1245_/Q VGND VGND VPWR VPWR _0824_/C sky130_fd_sc_hd__and4_2
X_0747_ _0760_/A _0747_/B _0747_/C VGND VGND VPWR VPWR _1214_/D sky130_fd_sc_hd__and3_2
X_0678_ _1163_/Q _0678_/B VGND VGND VPWR VPWR _0678_/X sky130_fd_sc_hd__or2_2
XFILLER_16_35 VGND VGND VPWR VPWR sky130_fd_sc_hd__fill_1
XFILLER_29_249 VGND VGND VPWR VPWR sky130_fd_sc_hd__decap_3
XFILLER_37_260 VGND VGND VPWR VPWR sky130_fd_sc_hd__fill_1
XFILLER_4_304 VGND VGND VPWR VPWR sky130_fd_sc_hd__decap_3
XFILLER_11_193 VGND VGND VPWR VPWR sky130_fd_sc_hd__decap_3
X_0601_ _1140_/Q _1131_/Q _0600_/B VGND VGND VPWR VPWR _0601_/Y sky130_fd_sc_hd__o21ai_2
XTAP_TAPCELL_ROW_13_177 VGND VPWR sky130_fd_sc_hd__tapvpwrvgnd_1
XFILLER_21_3 VGND VGND VPWR VPWR sky130_fd_sc_hd__decap_3
X_1015_ _1017_/A1 _1017_/A2 _1016_/B1 VGND VGND VPWR VPWR _1015_/X sky130_fd_sc_hd__o21a_2
XFILLER_27_78 VGND VGND VPWR VPWR sky130_fd_sc_hd__fill_2
XFILLER_40_233 VGND VGND VPWR VPWR sky130_fd_sc_hd__fill_1
XFILLER_43_11 VGND VGND VPWR VPWR sky130_fd_sc_hd__fill_2
XFILLER_43_44 VGND VGND VPWR VPWR sky130_fd_sc_hd__decap_3
XTAP_TAPCELL_ROW_27_247 VGND VPWR sky130_fd_sc_hd__tapvpwrvgnd_1
XFILLER_40_288 VGND VGND VPWR VPWR sky130_fd_sc_hd__decap_3
XFILLER_43_66 VGND VGND VPWR VPWR sky130_fd_sc_hd__decap_3
XFILLER_43_99 VGND VGND VPWR VPWR sky130_fd_sc_hd__decap_3
XFILLER_4_101 VGND VGND VPWR VPWR sky130_fd_sc_hd__fill_1
XFILLER_4_123 VGND VGND VPWR VPWR sky130_fd_sc_hd__decap_3
XPHY_EDGE_ROW_31_Left_83 VGND VGND VPWR VPWR sky130_fd_sc_hd__decap_3
XFILLER_16_230 VGND VGND VPWR VPWR sky130_fd_sc_hd__fill_1
XTAP_TAPCELL_ROW_18_203 VGND VPWR sky130_fd_sc_hd__tapvpwrvgnd_1
XFILLER_31_255 VGND VGND VPWR VPWR sky130_fd_sc_hd__decap_3
XTAP_TAPCELL_ROW_1_115 VGND VPWR sky130_fd_sc_hd__tapvpwrvgnd_1
XFILLER_22_200 VGND VGND VPWR VPWR sky130_fd_sc_hd__decap_3
XTAP_TAPCELL_ROW_32_272 VGND VPWR sky130_fd_sc_hd__tapvpwrvgnd_1
XFILLER_49_108 VGND VGND VPWR VPWR sky130_fd_sc_hd__decap_3
XFILLER_38_88 VGND VGND VPWR VPWR sky130_fd_sc_hd__fill_1
XFILLER_45_303 VGND VGND VPWR VPWR sky130_fd_sc_hd__decap_3
XFILLER_48_141 VGND VGND VPWR VPWR sky130_fd_sc_hd__decap_3
XFILLER_48_174 VGND VGND VPWR VPWR sky130_fd_sc_hd__decap_3
XTAP_TAPCELL_ROW_46_342 VGND VPWR sky130_fd_sc_hd__tapvpwrvgnd_1
X_0995_ _1042_/A1 _1042_/A2 _1042_/B1 VGND VGND VPWR VPWR _0995_/X sky130_fd_sc_hd__o21a_2
XFILLER_24_35 VGND VGND VPWR VPWR sky130_fd_sc_hd__fill_2
XFILLER_24_57 VGND VGND VPWR VPWR sky130_fd_sc_hd__decap_3
XFILLER_10_247 VGND VGND VPWR VPWR sky130_fd_sc_hd__decap_3
XFILLER_40_67 VGND VGND VPWR VPWR sky130_fd_sc_hd__fill_2
Xclkbuf_leaf_4_i_clk clkload1/A VGND VGND VPWR VPWR _1119_/CLK sky130_fd_sc_hd__clkbuf_8
XFILLER_49_76 VGND VGND VPWR VPWR sky130_fd_sc_hd__fill_2
Xhold281 _1136_/Q VGND VGND VPWR VPWR hold281/X sky130_fd_sc_hd__dlygate4sd3_1
Xhold270 _1082_/Q VGND VGND VPWR VPWR hold270/X sky130_fd_sc_hd__dlygate4sd3_1
XFILLER_45_155 VGND VGND VPWR VPWR sky130_fd_sc_hd__decap_3
XFILLER_45_166 VGND VGND VPWR VPWR sky130_fd_sc_hd__fill_2
X_0780_ _0780_/A _0780_/B _0780_/C _0780_/D VGND VGND VPWR VPWR _0780_/X sky130_fd_sc_hd__and4_2
XFILLER_36_144 VGND VGND VPWR VPWR sky130_fd_sc_hd__decap_3
X_1263_ _1268_/CLK _1263_/D load_slew108/X VGND VGND VPWR VPWR _1263_/Q sky130_fd_sc_hd__dfrtp_2
Xinput5 i_byte_cnt_reg[4] VGND VGND VPWR VPWR input5/X sky130_fd_sc_hd__clkdlybuf4s25_1
X_1194_ _1236_/CLK _1194_/D _1042_/B1 VGND VGND VPWR VPWR _1194_/Q sky130_fd_sc_hd__dfrtp_2
XFILLER_51_103 VGND VGND VPWR VPWR sky130_fd_sc_hd__decap_3
XFILLER_51_125 VGND VGND VPWR VPWR sky130_fd_sc_hd__fill_2
XFILLER_51_147 VGND VGND VPWR VPWR sky130_fd_sc_hd__decap_3
XFILLER_51_169 VGND VGND VPWR VPWR sky130_fd_sc_hd__decap_3
XFILLER_10_15 VGND VGND VPWR VPWR sky130_fd_sc_hd__decap_3
X_0978_ _1063_/A1 _1063_/A2 _1064_/B1 VGND VGND VPWR VPWR _0978_/X sky130_fd_sc_hd__o21a_2
XFILLER_15_306 VGND VGND VPWR VPWR sky130_fd_sc_hd__fill_2
XFILLER_27_166 VGND VGND VPWR VPWR sky130_fd_sc_hd__fill_2
XFILLER_42_114 VGND VGND VPWR VPWR sky130_fd_sc_hd__decap_3
XFILLER_42_147 VGND VGND VPWR VPWR sky130_fd_sc_hd__decap_3
XFILLER_50_180 VGND VGND VPWR VPWR sky130_fd_sc_hd__decap_3
XFILLER_51_11 VGND VGND VPWR VPWR sky130_fd_sc_hd__decap_3
XFILLER_51_55 VGND VGND VPWR VPWR sky130_fd_sc_hd__fill_1
XFILLER_51_66 VGND VGND VPWR VPWR sky130_fd_sc_hd__decap_3
XFILLER_41_180 VGND VGND VPWR VPWR sky130_fd_sc_hd__fill_1
X_0901_ _1161_/Q _1081_/Q input36/X _0917_/S _0677_/Y VGND VGND VPWR VPWR _0901_/X
+ sky130_fd_sc_hd__a221o_2
X_0832_ _1170_/Q _1277_/Q _1275_/Q _1272_/Q VGND VGND VPWR VPWR _0833_/B sky130_fd_sc_hd__or4_2
X_0763_ _0561_/Y _0760_/B _0762_/X VGND VGND VPWR VPWR _0763_/Y sky130_fd_sc_hd__a21oi_2
XFILLER_51_3 VGND VGND VPWR VPWR sky130_fd_sc_hd__decap_3
X_0694_ _0695_/A _1075_/Q VGND VGND VPWR VPWR _0694_/X sky130_fd_sc_hd__or2_2
XFILLER_24_114 VGND VGND VPWR VPWR sky130_fd_sc_hd__decap_3
X_1246_ clkload9/A _1246_/D _1054_/X VGND VGND VPWR VPWR _1246_/Q sky130_fd_sc_hd__dfrtp_2
X_1177_ _1192_/CLK _1177_/D load_slew117/X VGND VGND VPWR VPWR _1177_/Q sky130_fd_sc_hd__dfrtp_2
XFILLER_32_180 VGND VGND VPWR VPWR sky130_fd_sc_hd__fill_2
XFILLER_47_217 VGND VGND VPWR VPWR sky130_fd_sc_hd__decap_3
XFILLER_47_228 VGND VGND VPWR VPWR sky130_fd_sc_hd__decap_3
XFILLER_15_169 VGND VGND VPWR VPWR sky130_fd_sc_hd__decap_3
XFILLER_30_106 VGND VGND VPWR VPWR sky130_fd_sc_hd__decap_3
XFILLER_46_44 VGND VGND VPWR VPWR sky130_fd_sc_hd__decap_3
XFILLER_30_139 VGND VGND VPWR VPWR sky130_fd_sc_hd__fill_1
XFILLER_16_6 VGND VGND VPWR VPWR sky130_fd_sc_hd__fill_1
XFILLER_46_250 VGND VGND VPWR VPWR sky130_fd_sc_hd__fill_2
X_1100_ clkload6/A _1100_/D VGND VGND VPWR VPWR _1100_/Q sky130_fd_sc_hd__dfxtp_2
X_1031_ _1036_/A1 _1036_/A2 _1036_/B1 VGND VGND VPWR VPWR _1031_/X sky130_fd_sc_hd__o21a_2
XFILLER_21_139 VGND VGND VPWR VPWR sky130_fd_sc_hd__fill_1
Xinput41 i_transmit_data[5] VGND VGND VPWR VPWR input41/X sky130_fd_sc_hd__clkdlybuf4s25_1
Xinput30 i_slave_addr_reg[1] VGND VGND VPWR VPWR _0687_/A sky130_fd_sc_hd__clkdlybuf4s25_1
X_0815_ _0815_/A _0815_/B _0815_/C VGND VGND VPWR VPWR _1245_/D sky130_fd_sc_hd__nor3_2
X_0746_ _1214_/Q _1213_/Q VGND VGND VPWR VPWR _0747_/C sky130_fd_sc_hd__nand2_2
XFILLER_29_228 VGND VGND VPWR VPWR sky130_fd_sc_hd__decap_3
X_0677_ _1163_/Q _0678_/B VGND VGND VPWR VPWR _0677_/Y sky130_fd_sc_hd__nor2_2
XFILLER_16_58 VGND VGND VPWR VPWR sky130_fd_sc_hd__decap_3
X_1229_ _1236_/CLK _1229_/D _1037_/X VGND VGND VPWR VPWR _1229_/Q sky130_fd_sc_hd__dfrtp_2
XFILLER_12_139 VGND VGND VPWR VPWR sky130_fd_sc_hd__fill_1
XFILLER_11_150 VGND VGND VPWR VPWR sky130_fd_sc_hd__decap_3
XFILLER_11_172 VGND VGND VPWR VPWR sky130_fd_sc_hd__decap_3
XFILLER_7_143 VGND VGND VPWR VPWR sky130_fd_sc_hd__decap_3
X_0600_ _0578_/X _0600_/B _0600_/C VGND VGND VPWR VPWR _1132_/D sky130_fd_sc_hd__and3b_2
XTAP_TAPCELL_ROW_13_178 VGND VPWR sky130_fd_sc_hd__tapvpwrvgnd_1
XFILLER_14_3 VGND VGND VPWR VPWR sky130_fd_sc_hd__fill_2
XFILLER_19_250 VGND VGND VPWR VPWR sky130_fd_sc_hd__fill_2
XFILLER_19_272 VGND VGND VPWR VPWR sky130_fd_sc_hd__decap_3
XFILLER_34_253 VGND VGND VPWR VPWR sky130_fd_sc_hd__decap_3
X_1014_ _1017_/A1 _1017_/A2 _1016_/B1 VGND VGND VPWR VPWR _1014_/X sky130_fd_sc_hd__o21a_2
XFILLER_8_70 VGND VGND VPWR VPWR sky130_fd_sc_hd__fill_1
X_1290__130 VGND VGND VPWR VPWR _1290__130/HI _1290_/A sky130_fd_sc_hd__conb_1
X_0729_ _0724_/X _0729_/B _0729_/C VGND VGND VPWR VPWR _1211_/D sky130_fd_sc_hd__and3b_2
XFILLER_27_46 VGND VGND VPWR VPWR sky130_fd_sc_hd__decap_3
XFILLER_27_57 VGND VGND VPWR VPWR sky130_fd_sc_hd__decap_3
XFILLER_25_231 VGND VGND VPWR VPWR sky130_fd_sc_hd__fill_1
XFILLER_40_212 VGND VGND VPWR VPWR sky130_fd_sc_hd__decap_3
XFILLER_40_256 VGND VGND VPWR VPWR sky130_fd_sc_hd__decap_3
XFILLER_43_78 VGND VGND VPWR VPWR sky130_fd_sc_hd__decap_3
XTAP_TAPCELL_ROW_27_248 VGND VPWR sky130_fd_sc_hd__tapvpwrvgnd_1
XTAP_TAPCELL_ROW_10_159 VGND VPWR sky130_fd_sc_hd__tapvpwrvgnd_1
XFILLER_48_301 VGND VGND VPWR VPWR sky130_fd_sc_hd__decap_3
XFILLER_16_264 VGND VGND VPWR VPWR sky130_fd_sc_hd__decap_3
XFILLER_16_286 VGND VGND VPWR VPWR sky130_fd_sc_hd__decap_3
XFILLER_31_278 VGND VGND VPWR VPWR sky130_fd_sc_hd__fill_2
XFILLER_31_289 VGND VGND VPWR VPWR sky130_fd_sc_hd__decap_3
XTAP_TAPCELL_ROW_1_116 VGND VPWR sky130_fd_sc_hd__tapvpwrvgnd_1
XTAP_TAPCELL_ROW_24_229 VGND VPWR sky130_fd_sc_hd__tapvpwrvgnd_1
XTAP_TAPCELL_ROW_32_273 VGND VPWR sky130_fd_sc_hd__tapvpwrvgnd_1
XFILLER_38_67 VGND VGND VPWR VPWR sky130_fd_sc_hd__fill_2
XFILLER_13_234 VGND VGND VPWR VPWR sky130_fd_sc_hd__decap_3
XFILLER_13_256 VGND VGND VPWR VPWR sky130_fd_sc_hd__decap_3
XFILLER_13_278 VGND VGND VPWR VPWR sky130_fd_sc_hd__fill_2
XFILLER_13_289 VGND VGND VPWR VPWR sky130_fd_sc_hd__decap_3
XFILLER_36_304 VGND VGND VPWR VPWR sky130_fd_sc_hd__decap_3
XFILLER_48_153 VGND VGND VPWR VPWR sky130_fd_sc_hd__decap_3
XFILLER_48_186 VGND VGND VPWR VPWR sky130_fd_sc_hd__decap_3
XFILLER_48_197 VGND VGND VPWR VPWR sky130_fd_sc_hd__decap_3
XTAP_TAPCELL_ROW_46_343 VGND VPWR sky130_fd_sc_hd__tapvpwrvgnd_1
X_0994_ _1042_/A1 _1042_/A2 _1040_/B1 VGND VGND VPWR VPWR _0994_/X sky130_fd_sc_hd__o21a_2
XFILLER_8_260 VGND VGND VPWR VPWR sky130_fd_sc_hd__decap_3
XFILLER_27_304 VGND VGND VPWR VPWR sky130_fd_sc_hd__decap_3
XFILLER_42_307 VGND VGND VPWR VPWR sky130_fd_sc_hd__fill_1
XTAP_TAPCELL_ROW_20_210 VGND VPWR sky130_fd_sc_hd__tapvpwrvgnd_1
Xhold260 _1169_/Q VGND VGND VPWR VPWR hold260/X sky130_fd_sc_hd__dlygate4sd3_1
Xhold271 _1242_/Q VGND VGND VPWR VPWR _0566_/A sky130_fd_sc_hd__dlygate4sd3_1
XFILLER_49_44 VGND VGND VPWR VPWR sky130_fd_sc_hd__fill_2
XFILLER_49_99 VGND VGND VPWR VPWR sky130_fd_sc_hd__decap_3
Xhold282 _1171_/Q VGND VGND VPWR VPWR hold282/X sky130_fd_sc_hd__dlygate4sd3_1
XFILLER_45_189 VGND VGND VPWR VPWR sky130_fd_sc_hd__decap_3
XTAP_TAPCELL_ROW_43_324 VGND VPWR sky130_fd_sc_hd__tapvpwrvgnd_1
XFILLER_36_167 VGND VGND VPWR VPWR sky130_fd_sc_hd__decap_3
X_1262_ _1262_/CLK _1262_/D _1027_/B1 VGND VGND VPWR VPWR _1262_/Q sky130_fd_sc_hd__dfrtp_2
Xinput6 i_byte_cnt_reg[5] VGND VGND VPWR VPWR input6/X sky130_fd_sc_hd__clkdlybuf4s25_1
X_1193_ _1212_/CLK _1193_/D _1020_/B1 VGND VGND VPWR VPWR _1193_/Q sky130_fd_sc_hd__dfrtp_2
XFILLER_51_137 VGND VGND VPWR VPWR sky130_fd_sc_hd__decap_3
XFILLER_51_159 VGND VGND VPWR VPWR sky130_fd_sc_hd__decap_3
XFILLER_10_27 VGND VGND VPWR VPWR sky130_fd_sc_hd__fill_1
X_0977_ _1061_/A1 _1061_/A2 _1067_/B1 VGND VGND VPWR VPWR _0977_/X sky130_fd_sc_hd__o21a_2
XFILLER_35_57 VGND VGND VPWR VPWR sky130_fd_sc_hd__fill_1
XFILLER_35_79 VGND VGND VPWR VPWR sky130_fd_sc_hd__fill_2
XFILLER_42_126 VGND VGND VPWR VPWR sky130_fd_sc_hd__decap_3
XFILLER_42_159 VGND VGND VPWR VPWR sky130_fd_sc_hd__decap_3
XFILLER_50_192 VGND VGND VPWR VPWR sky130_fd_sc_hd__decap_3
XFILLER_51_23 VGND VGND VPWR VPWR sky130_fd_sc_hd__decap_3
XFILLER_51_78 VGND VGND VPWR VPWR sky130_fd_sc_hd__decap_3
XPHY_EDGE_ROW_14_Right_14 VGND VGND VPWR VPWR sky130_fd_sc_hd__decap_3
XPHY_EDGE_ROW_23_Right_23 VGND VGND VPWR VPWR sky130_fd_sc_hd__decap_3
X_0900_ _0546_/Y _1110_/Q hold160/X VGND VGND VPWR VPWR _0900_/X sky130_fd_sc_hd__a21o_2
XPHY_EDGE_ROW_32_Right_32 VGND VGND VPWR VPWR sky130_fd_sc_hd__decap_3
X_0831_ _1278_/Q _1273_/Q _1276_/Q _1271_/Q VGND VGND VPWR VPWR _0833_/A sky130_fd_sc_hd__or4_2
X_0762_ _0780_/A _0780_/B hold251/X VGND VGND VPWR VPWR _0762_/X sky130_fd_sc_hd__a21o_2
X_0693_ _0693_/A _1073_/Q VGND VGND VPWR VPWR _0693_/X sky130_fd_sc_hd__xor2_2
XPHY_EDGE_ROW_41_Right_41 VGND VGND VPWR VPWR sky130_fd_sc_hd__decap_3
XFILLER_24_126 VGND VGND VPWR VPWR sky130_fd_sc_hd__decap_3
XFILLER_49_270 VGND VGND VPWR VPWR sky130_fd_sc_hd__decap_3
XFILLER_49_281 VGND VGND VPWR VPWR sky130_fd_sc_hd__decap_3
X_1245_ clkload9/A _1245_/D _1053_/X VGND VGND VPWR VPWR _1245_/Q sky130_fd_sc_hd__dfrtp_2
Xclkbuf_leaf_3_i_clk clkload1/A VGND VGND VPWR VPWR _1268_/CLK sky130_fd_sc_hd__clkbuf_8
X_1176_ _1191_/CLK _1176_/D fanout101/X VGND VGND VPWR VPWR _1176_/Q sky130_fd_sc_hd__dfrtp_2
XPHY_EDGE_ROW_50_Right_50 VGND VGND VPWR VPWR sky130_fd_sc_hd__decap_3
XFILLER_15_148 VGND VGND VPWR VPWR sky130_fd_sc_hd__fill_1
XFILLER_46_78 VGND VGND VPWR VPWR sky130_fd_sc_hd__decap_3
XFILLER_7_17 VGND VGND VPWR VPWR sky130_fd_sc_hd__fill_2
X_1030_ _1036_/A1 _1036_/A2 _1036_/B1 VGND VGND VPWR VPWR _1030_/X sky130_fd_sc_hd__o21a_2
XFILLER_14_170 VGND VGND VPWR VPWR sky130_fd_sc_hd__decap_3
Xinput31 i_slave_addr_reg[2] VGND VGND VPWR VPWR _0690_/A sky130_fd_sc_hd__clkdlybuf4s25_1
Xinput20 i_config_reg[4] VGND VGND VPWR VPWR _1176_/D sky130_fd_sc_hd__clkdlybuf4s25_1
X_0814_ _1244_/Q _1245_/Q _0814_/C VGND VGND VPWR VPWR _0815_/C sky130_fd_sc_hd__and3_2
Xinput42 i_transmit_data[6] VGND VGND VPWR VPWR input42/X sky130_fd_sc_hd__clkdlybuf4s25_1
X_0745_ _1214_/Q _1213_/Q VGND VGND VPWR VPWR _0747_/B sky130_fd_sc_hd__or2_2
X_0676_ _1161_/Q _0545_/Y _1192_/D _0974_/S VGND VGND VPWR VPWR _1161_/D sky130_fd_sc_hd__a22o_2
XFILLER_37_251 VGND VGND VPWR VPWR sky130_fd_sc_hd__decap_3
X_1228_ _1262_/CLK _1228_/D _1036_/X VGND VGND VPWR VPWR _1228_/Q sky130_fd_sc_hd__dfrtp_2
X_1159_ _1233_/CLK _1159_/D fanout119/X VGND VGND VPWR VPWR _1159_/Q sky130_fd_sc_hd__dfstp_2
XTAP_TAPCELL_ROW_7_144 VGND VPWR sky130_fd_sc_hd__tapvpwrvgnd_1
XFILLER_28_251 VGND VGND VPWR VPWR sky130_fd_sc_hd__fill_1
XFILLER_43_298 VGND VGND VPWR VPWR sky130_fd_sc_hd__decap_3
XFILLER_7_111 VGND VGND VPWR VPWR sky130_fd_sc_hd__fill_1
XFILLER_7_122 VGND VGND VPWR VPWR sky130_fd_sc_hd__fill_1
XFILLER_22_91 VGND VGND VPWR VPWR sky130_fd_sc_hd__fill_1
XFILLER_7_133 VGND VGND VPWR VPWR sky130_fd_sc_hd__fill_1
XFILLER_7_166 VGND VGND VPWR VPWR sky130_fd_sc_hd__fill_2
X_1013_ _1017_/A1 _1017_/A2 _1016_/B1 VGND VGND VPWR VPWR _1013_/X sky130_fd_sc_hd__o21a_2
XFILLER_8_82 VGND VGND VPWR VPWR sky130_fd_sc_hd__fill_2
XFILLER_8_60 VGND VGND VPWR VPWR sky130_fd_sc_hd__fill_2
X_0728_ _0728_/A _0728_/B _0728_/C VGND VGND VPWR VPWR _0729_/C sky130_fd_sc_hd__and3_2
X_0659_ _1161_/Q _1166_/Q VGND VGND VPWR VPWR _0917_/S sky130_fd_sc_hd__nor2_2
XPHY_EDGE_ROW_4_Right_4 VGND VGND VPWR VPWR sky130_fd_sc_hd__decap_3
XFILLER_25_265 VGND VGND VPWR VPWR sky130_fd_sc_hd__fill_2
XFILLER_25_298 VGND VGND VPWR VPWR sky130_fd_sc_hd__decap_3
XFILLER_40_224 VGND VGND VPWR VPWR sky130_fd_sc_hd__decap_3
XFILLER_40_268 VGND VGND VPWR VPWR sky130_fd_sc_hd__decap_3
XFILLER_43_35 VGND VGND VPWR VPWR sky130_fd_sc_hd__decap_3
XFILLER_43_57 VGND VGND VPWR VPWR sky130_fd_sc_hd__decap_3
XFILLER_4_29 VGND VGND VPWR VPWR sky130_fd_sc_hd__decap_3
XFILLER_17_91 VGND VGND VPWR VPWR sky130_fd_sc_hd__decap_3
XFILLER_31_246 VGND VGND VPWR VPWR sky130_fd_sc_hd__decap_3
XFILLER_39_302 VGND VGND VPWR VPWR sky130_fd_sc_hd__decap_3
XTAP_TAPCELL_ROW_1_117 VGND VPWR sky130_fd_sc_hd__tapvpwrvgnd_1
XFILLER_8_9 VGND VGND VPWR VPWR sky130_fd_sc_hd__decap_3
XFILLER_13_268 VGND VGND VPWR VPWR sky130_fd_sc_hd__fill_2
XFILLER_9_228 VGND VGND VPWR VPWR sky130_fd_sc_hd__decap_3
XFILLER_48_165 VGND VGND VPWR VPWR sky130_fd_sc_hd__decap_3
X_0993_ _1042_/A1 _1042_/A2 _1040_/B1 VGND VGND VPWR VPWR _0993_/X sky130_fd_sc_hd__o21a_2
XFILLER_24_48 VGND VGND VPWR VPWR sky130_fd_sc_hd__decap_3
XTAP_TAPCELL_ROW_20_211 VGND VPWR sky130_fd_sc_hd__tapvpwrvgnd_1
Xhold250 _1200_/Q VGND VGND VPWR VPWR hold250/X sky130_fd_sc_hd__dlygate4sd3_1
Xhold261 _0682_/X VGND VGND VPWR VPWR _1170_/D sky130_fd_sc_hd__dlygate4sd3_1
Xhold283 _1248_/Q VGND VGND VPWR VPWR _0567_/A sky130_fd_sc_hd__dlygate4sd3_1
Xhold272 _1086_/Q VGND VGND VPWR VPWR hold272/X sky130_fd_sc_hd__dlygate4sd3_1
XFILLER_45_113 VGND VGND VPWR VPWR sky130_fd_sc_hd__decap_3
XTAP_TAPCELL_ROW_43_325 VGND VPWR sky130_fd_sc_hd__tapvpwrvgnd_1
XFILLER_30_80 VGND VGND VPWR VPWR sky130_fd_sc_hd__fill_1
XFILLER_39_6 VGND VGND VPWR VPWR sky130_fd_sc_hd__decap_3
X_1261_ _1262_/CLK _1261_/D _1027_/B1 VGND VGND VPWR VPWR _1261_/Q sky130_fd_sc_hd__dfrtp_2
XFILLER_36_179 VGND VGND VPWR VPWR sky130_fd_sc_hd__decap_3
XFILLER_51_116 VGND VGND VPWR VPWR sky130_fd_sc_hd__decap_3
Xinput7 i_byte_cnt_reg[6] VGND VGND VPWR VPWR input7/X sky130_fd_sc_hd__clkdlybuf4s25_1
X_1192_ _1192_/CLK _1192_/D fanout116/X VGND VGND VPWR VPWR _1192_/Q sky130_fd_sc_hd__dfrtp_2
X_0976_ _1027_/A1 _1027_/A2 _1049_/B1 VGND VGND VPWR VPWR _0976_/X sky130_fd_sc_hd__o21a_2
XFILLER_27_113 VGND VGND VPWR VPWR sky130_fd_sc_hd__decap_3
XFILLER_42_105 VGND VGND VPWR VPWR sky130_fd_sc_hd__decap_3
XFILLER_42_138 VGND VGND VPWR VPWR sky130_fd_sc_hd__fill_2
XFILLER_50_171 VGND VGND VPWR VPWR sky130_fd_sc_hd__decap_3
XFILLER_51_46 VGND VGND VPWR VPWR sky130_fd_sc_hd__decap_3
XFILLER_51_57 VGND VGND VPWR VPWR sky130_fd_sc_hd__decap_3
XFILLER_4_3 VGND VGND VPWR VPWR sky130_fd_sc_hd__fill_1
XFILLER_41_160 VGND VGND VPWR VPWR sky130_fd_sc_hd__decap_3
X_0830_ _0830_/A _0830_/B VGND VGND VPWR VPWR _1250_/D sky130_fd_sc_hd__nor2_2
X_0761_ _1217_/Q _1218_/Q _1219_/Q _1220_/Q VGND VGND VPWR VPWR _0780_/B sky130_fd_sc_hd__and4_2
X_0692_ _0692_/A _1070_/Q VGND VGND VPWR VPWR _0692_/Y sky130_fd_sc_hd__nand2_2
XFILLER_37_3 VGND VGND VPWR VPWR sky130_fd_sc_hd__decap_3
XFILLER_49_293 VGND VGND VPWR VPWR sky130_fd_sc_hd__decap_3
X_1244_ clkload9/A _1244_/D _1052_/X VGND VGND VPWR VPWR _1244_/Q sky130_fd_sc_hd__dfrtp_2
X_1175_ _1233_/CLK _1175_/D load_slew115/X VGND VGND VPWR VPWR _1175_/Q sky130_fd_sc_hd__dfrtp_2
XFILLER_32_171 VGND VGND VPWR VPWR sky130_fd_sc_hd__decap_3
X_0959_ hold244/X _1172_/Q _0970_/S VGND VGND VPWR VPWR _0959_/X sky130_fd_sc_hd__mux2_1
XFILLER_46_68 VGND VGND VPWR VPWR sky130_fd_sc_hd__decap_3
XFILLER_47_208 VGND VGND VPWR VPWR sky130_fd_sc_hd__decap_3
XPHY_EDGE_ROW_6_Left_58 VGND VGND VPWR VPWR sky130_fd_sc_hd__decap_3
XFILLER_46_241 VGND VGND VPWR VPWR sky130_fd_sc_hd__decap_3
XFILLER_46_296 VGND VGND VPWR VPWR sky130_fd_sc_hd__decap_3
Xinput43 i_transmit_data[7] VGND VGND VPWR VPWR input43/X sky130_fd_sc_hd__clkdlybuf4s25_1
Xinput32 i_slave_addr_reg[3] VGND VGND VPWR VPWR _0693_/A sky130_fd_sc_hd__clkdlybuf4s25_1
Xinput21 i_config_reg[5] VGND VGND VPWR VPWR _1261_/D sky130_fd_sc_hd__clkdlybuf4s25_1
Xinput10 i_clk_div_lsb[2] VGND VGND VPWR VPWR _0621_/A sky130_fd_sc_hd__clkdlybuf4s25_1
X_0813_ _1244_/Q _0814_/C _1245_/Q VGND VGND VPWR VPWR _0815_/B sky130_fd_sc_hd__a21oi_2
X_0744_ _0708_/A _0708_/B _0708_/C _0778_/A VGND VGND VPWR VPWR _0760_/A sky130_fd_sc_hd__o31a_2
X_0675_ _1162_/Q _0554_/Y _0737_/S hold234/X _0674_/X VGND VGND VPWR VPWR _1162_/D
+ sky130_fd_sc_hd__a221o_2
X_1227_ _1227_/CLK _1227_/D _1035_/X VGND VGND VPWR VPWR _1227_/Q sky130_fd_sc_hd__dfrtp_2
X_1158_ clkload8/A _1158_/D _1006_/X VGND VGND VPWR VPWR _1158_/Q sky130_fd_sc_hd__dfrtp_2
XFILLER_16_49 VGND VGND VPWR VPWR sky130_fd_sc_hd__decap_3
XFILLER_20_141 VGND VGND VPWR VPWR sky130_fd_sc_hd__fill_2
XFILLER_32_37 VGND VGND VPWR VPWR sky130_fd_sc_hd__decap_3
X_1089_ _1119_/CLK _1089_/D load_slew108/X VGND VGND VPWR VPWR _1089_/Q sky130_fd_sc_hd__dfrtp_2
XFILLER_32_59 VGND VGND VPWR VPWR sky130_fd_sc_hd__decap_3
XFILLER_4_307 VGND VGND VPWR VPWR sky130_fd_sc_hd__fill_1
XTAP_TAPCELL_ROW_7_145 VGND VPWR sky130_fd_sc_hd__tapvpwrvgnd_1
XFILLER_43_244 VGND VGND VPWR VPWR sky130_fd_sc_hd__fill_2
XFILLER_11_196 VGND VGND VPWR VPWR sky130_fd_sc_hd__decap_3
XFILLER_22_81 VGND VGND VPWR VPWR sky130_fd_sc_hd__decap_3
Xclkbuf_leaf_2_i_clk clkbuf_leaf_2_i_clk/A VGND VGND VPWR VPWR _1212_/CLK sky130_fd_sc_hd__clkbuf_8
XFILLER_19_263 VGND VGND VPWR VPWR sky130_fd_sc_hd__decap_3
XFILLER_21_6 VGND VGND VPWR VPWR sky130_fd_sc_hd__fill_1
X_1012_ _1017_/A1 _1017_/A2 _1016_/B1 VGND VGND VPWR VPWR _1012_/X sky130_fd_sc_hd__o21a_2
X_0727_ _0536_/Y _1205_/Q _1206_/Q _0535_/Y _0720_/X VGND VGND VPWR VPWR _0728_/C
+ sky130_fd_sc_hd__a221oi_2
X_0658_ _0658_/A _1198_/Q VGND VGND VPWR VPWR _1191_/D sky130_fd_sc_hd__and2_2
X_0589_ _1137_/Q _0592_/A _0600_/B VGND VGND VPWR VPWR _0589_/Y sky130_fd_sc_hd__o21ai_2
XFILLER_43_69 VGND VGND VPWR VPWR sky130_fd_sc_hd__decap_3
XFILLER_4_126 VGND VGND VPWR VPWR sky130_fd_sc_hd__decap_3
XFILLER_16_200 VGND VGND VPWR VPWR sky130_fd_sc_hd__fill_1
XFILLER_16_299 VGND VGND VPWR VPWR sky130_fd_sc_hd__decap_3
XFILLER_31_258 VGND VGND VPWR VPWR sky130_fd_sc_hd__decap_3
XPHY_EDGE_ROW_9_Left_61 VGND VGND VPWR VPWR sky130_fd_sc_hd__decap_3
XTAP_TAPCELL_ROW_1_118 VGND VPWR sky130_fd_sc_hd__tapvpwrvgnd_1
XFILLER_13_28 VGND VGND VPWR VPWR sky130_fd_sc_hd__decap_3
XFILLER_38_25 VGND VGND VPWR VPWR sky130_fd_sc_hd__decap_3
XFILLER_38_58 VGND VGND VPWR VPWR sky130_fd_sc_hd__decap_3
XFILLER_45_306 VGND VGND VPWR VPWR sky130_fd_sc_hd__fill_2
XFILLER_13_225 VGND VGND VPWR VPWR sky130_fd_sc_hd__decap_3
XPHY_EDGE_ROW_35_Left_87 VGND VGND VPWR VPWR sky130_fd_sc_hd__decap_3
XFILLER_48_144 VGND VGND VPWR VPWR sky130_fd_sc_hd__decap_3
XFILLER_48_177 VGND VGND VPWR VPWR sky130_fd_sc_hd__decap_3
Xclkbuf_leaf_20_i_clk clkbuf_leaf_2_i_clk/A VGND VGND VPWR VPWR clkload5/A sky130_fd_sc_hd__clkbuf_8
X_0992_ _1061_/A1 _1061_/A2 _1040_/B1 VGND VGND VPWR VPWR _0992_/X sky130_fd_sc_hd__o21a_2
XFILLER_39_111 VGND VGND VPWR VPWR sky130_fd_sc_hd__fill_1
XFILLER_39_177 VGND VGND VPWR VPWR sky130_fd_sc_hd__fill_1
XFILLER_24_27 VGND VGND VPWR VPWR sky130_fd_sc_hd__fill_1
XFILLER_39_199 VGND VGND VPWR VPWR sky130_fd_sc_hd__decap_3
XFILLER_10_239 VGND VGND VPWR VPWR sky130_fd_sc_hd__fill_1
XFILLER_40_26 VGND VGND VPWR VPWR sky130_fd_sc_hd__fill_2
XTAP_TAPCELL_ROW_20_212 VGND VPWR sky130_fd_sc_hd__tapvpwrvgnd_1
Xhold240 _1269_/Q VGND VGND VPWR VPWR hold240/X sky130_fd_sc_hd__dlygate4sd3_1
Xhold251 _1232_/Q VGND VGND VPWR VPWR hold251/X sky130_fd_sc_hd__dlygate4sd3_1
Xhold262 _1084_/Q VGND VGND VPWR VPWR hold262/X sky130_fd_sc_hd__dlygate4sd3_1
Xhold284 _1185_/Q VGND VGND VPWR VPWR hold284/X sky130_fd_sc_hd__dlygate4sd3_1
Xhold273 _1163_/Q VGND VGND VPWR VPWR hold273/X sky130_fd_sc_hd__dlygate4sd3_1
XFILLER_18_306 VGND VGND VPWR VPWR sky130_fd_sc_hd__fill_2
XFILLER_45_158 VGND VGND VPWR VPWR sky130_fd_sc_hd__decap_3
XFILLER_45_169 VGND VGND VPWR VPWR sky130_fd_sc_hd__fill_1
XTAP_TAPCELL_ROW_51_370 VGND VPWR sky130_fd_sc_hd__tapvpwrvgnd_1
XTAP_TAPCELL_ROW_43_326 VGND VPWR sky130_fd_sc_hd__tapvpwrvgnd_1
X_1260_ _1262_/CLK _1260_/D _1027_/B1 VGND VGND VPWR VPWR _1260_/Q sky130_fd_sc_hd__dfrtp_2
Xinput8 i_byte_cnt_reg[7] VGND VGND VPWR VPWR input8/X sky130_fd_sc_hd__clkdlybuf4s25_1
X_1191_ _1191_/CLK _1191_/D fanout106/X VGND VGND VPWR VPWR _1191_/Q sky130_fd_sc_hd__dfrtp_2
XFILLER_51_106 VGND VGND VPWR VPWR sky130_fd_sc_hd__decap_3
X_0975_ _1210_/Q VGND VGND VPWR VPWR _0975_/X sky130_fd_sc_hd__buf_1
XFILLER_10_18 VGND VGND VPWR VPWR sky130_fd_sc_hd__decap_3
XFILLER_10_29 VGND VGND VPWR VPWR sky130_fd_sc_hd__fill_2
XFILLER_27_169 VGND VGND VPWR VPWR sky130_fd_sc_hd__decap_3
XFILLER_42_117 VGND VGND VPWR VPWR sky130_fd_sc_hd__decap_3
XFILLER_50_150 VGND VGND VPWR VPWR sky130_fd_sc_hd__decap_3
XFILLER_50_183 VGND VGND VPWR VPWR sky130_fd_sc_hd__decap_3
XFILLER_51_14 VGND VGND VPWR VPWR sky130_fd_sc_hd__decap_3
XFILLER_51_69 VGND VGND VPWR VPWR sky130_fd_sc_hd__decap_3
XFILLER_33_128 VGND VGND VPWR VPWR sky130_fd_sc_hd__decap_3
X_0760_ _0760_/A _0760_/B _0760_/C VGND VGND VPWR VPWR _1219_/D sky130_fd_sc_hd__and3_2
X_0691_ _0692_/A _1070_/Q VGND VGND VPWR VPWR _0691_/X sky130_fd_sc_hd__or2_2
XPHY_EDGE_ROW_38_Left_90 VGND VGND VPWR VPWR sky130_fd_sc_hd__decap_3
XFILLER_2_41 VGND VGND VPWR VPWR sky130_fd_sc_hd__fill_1
XFILLER_2_85 VGND VGND VPWR VPWR sky130_fd_sc_hd__decap_3
XFILLER_49_261 VGND VGND VPWR VPWR sky130_fd_sc_hd__decap_3
X_1243_ clkload9/A _1243_/D _1051_/X VGND VGND VPWR VPWR _1243_/Q sky130_fd_sc_hd__dfrtp_2
X_1174_ _1192_/CLK _1174_/D fanout116/X VGND VGND VPWR VPWR _1174_/Q sky130_fd_sc_hd__dfrtp_2
XPHY_EDGE_ROW_22_Left_74 VGND VGND VPWR VPWR sky130_fd_sc_hd__decap_3
XFILLER_24_117 VGND VGND VPWR VPWR sky130_fd_sc_hd__decap_3
X_0958_ _1128_/Q _0957_/Y _1192_/D VGND VGND VPWR VPWR _1128_/D sky130_fd_sc_hd__a21o_2
X_0889_ _0891_/A _1263_/Q VGND VGND VPWR VPWR _0890_/S sky130_fd_sc_hd__nand2_2
XFILLER_46_47 VGND VGND VPWR VPWR sky130_fd_sc_hd__decap_3
XFILLER_30_109 VGND VGND VPWR VPWR sky130_fd_sc_hd__decap_3
XFILLER_46_220 VGND VGND VPWR VPWR sky130_fd_sc_hd__decap_3
XFILLER_14_161 VGND VGND VPWR VPWR sky130_fd_sc_hd__decap_3
XFILLER_46_253 VGND VGND VPWR VPWR sky130_fd_sc_hd__decap_3
XTAP_TAPCELL_ROW_16_189 VGND VPWR sky130_fd_sc_hd__tapvpwrvgnd_1
Xinput33 i_slave_addr_reg[4] VGND VGND VPWR VPWR _0696_/A sky130_fd_sc_hd__clkdlybuf4s25_1
Xinput22 i_mode_reg[0] VGND VGND VPWR VPWR _0632_/A sky130_fd_sc_hd__clkdlybuf4s25_1
Xinput11 i_clk_div_lsb[3] VGND VGND VPWR VPWR _0621_/B sky130_fd_sc_hd__clkdlybuf4s25_1
X_0812_ _1244_/Q _0814_/C _0811_/Y VGND VGND VPWR VPWR _1244_/D sky130_fd_sc_hd__o21a_2
X_0743_ hold248/X _1229_/D _0778_/A VGND VGND VPWR VPWR _1213_/D sky130_fd_sc_hd__o21ai_2
X_0674_ _1179_/Q _1185_/Q _1160_/Q VGND VGND VPWR VPWR _0674_/X sky130_fd_sc_hd__and3b_2
XFILLER_37_220 VGND VGND VPWR VPWR sky130_fd_sc_hd__decap_3
X_1226_ _1226_/CLK _1226_/D _1034_/X VGND VGND VPWR VPWR _1226_/Q sky130_fd_sc_hd__dfrtp_2
X_1157_ clkload8/A _1157_/D _1005_/X VGND VGND VPWR VPWR _1157_/Q sky130_fd_sc_hd__dfrtp_2
XFILLER_32_49 VGND VGND VPWR VPWR sky130_fd_sc_hd__fill_2
X_1088_ _1278_/CLK _1088_/D load_slew99/X VGND VGND VPWR VPWR _1088_/Q sky130_fd_sc_hd__dfrtp_2
XTAP_TAPCELL_ROW_7_146 VGND VPWR sky130_fd_sc_hd__tapvpwrvgnd_1
XFILLER_28_242 VGND VGND VPWR VPWR sky130_fd_sc_hd__decap_3
XFILLER_28_253 VGND VGND VPWR VPWR sky130_fd_sc_hd__decap_3
XFILLER_43_201 VGND VGND VPWR VPWR sky130_fd_sc_hd__fill_2
XFILLER_11_153 VGND VGND VPWR VPWR sky130_fd_sc_hd__decap_3
XFILLER_11_175 VGND VGND VPWR VPWR sky130_fd_sc_hd__fill_2
XFILLER_22_71 VGND VGND VPWR VPWR sky130_fd_sc_hd__decap_3
XFILLER_7_113 VGND VGND VPWR VPWR sky130_fd_sc_hd__decap_3
XFILLER_7_146 VGND VGND VPWR VPWR sky130_fd_sc_hd__decap_3
XFILLER_7_157 VGND VGND VPWR VPWR sky130_fd_sc_hd__decap_3
XFILLER_19_231 VGND VGND VPWR VPWR sky130_fd_sc_hd__fill_1
XFILLER_19_275 VGND VGND VPWR VPWR sky130_fd_sc_hd__fill_2
X_1011_ _1017_/A1 _1017_/A2 _1016_/B1 VGND VGND VPWR VPWR _1011_/X sky130_fd_sc_hd__o21a_2
XFILLER_34_256 VGND VGND VPWR VPWR sky130_fd_sc_hd__decap_3
X_0726_ _0536_/Y _1205_/Q _1207_/Q _0534_/Y _0725_/X VGND VGND VPWR VPWR _0729_/B
+ sky130_fd_sc_hd__o221a_2
XTAP_TAPCELL_ROW_12_170 VGND VPWR sky130_fd_sc_hd__tapvpwrvgnd_1
X_0657_ _1106_/Q _1119_/Q _0733_/B VGND VGND VPWR VPWR _0680_/A sky130_fd_sc_hd__nor3_2
X_0588_ _0588_/A _0588_/B VGND VGND VPWR VPWR _1138_/D sky130_fd_sc_hd__nor2_2
XFILLER_27_49 VGND VGND VPWR VPWR sky130_fd_sc_hd__decap_3
XFILLER_40_215 VGND VGND VPWR VPWR sky130_fd_sc_hd__decap_3
XFILLER_43_26 VGND VGND VPWR VPWR sky130_fd_sc_hd__decap_3
X_1209_ _1211_/CLK _1209_/D _1017_/X VGND VGND VPWR VPWR _1209_/Q sky130_fd_sc_hd__dfrtp_2
XFILLER_40_259 VGND VGND VPWR VPWR sky130_fd_sc_hd__decap_3
XTAP_TAPCELL_ROW_35_284 VGND VPWR sky130_fd_sc_hd__tapvpwrvgnd_1
XFILLER_0_300 VGND VGND VPWR VPWR sky130_fd_sc_hd__decap_3
XFILLER_48_304 VGND VGND VPWR VPWR sky130_fd_sc_hd__decap_3
XFILLER_16_267 VGND VGND VPWR VPWR sky130_fd_sc_hd__decap_3
XFILLER_16_289 VGND VGND VPWR VPWR sky130_fd_sc_hd__decap_3
XFILLER_17_60 VGND VGND VPWR VPWR sky130_fd_sc_hd__decap_3
XFILLER_17_82 VGND VGND VPWR VPWR sky130_fd_sc_hd__decap_3
XFILLER_31_215 VGND VGND VPWR VPWR sky130_fd_sc_hd__decap_3
XTAP_TAPCELL_ROW_26_240 VGND VPWR sky130_fd_sc_hd__tapvpwrvgnd_1
XFILLER_12_3 VGND VGND VPWR VPWR sky130_fd_sc_hd__decap_3
XTAP_TAPCELL_ROW_49_354 VGND VPWR sky130_fd_sc_hd__tapvpwrvgnd_1
X_0709_ _1241_/Q _1069_/Q VGND VGND VPWR VPWR _0709_/X sky130_fd_sc_hd__and2b_2
XFILLER_38_37 VGND VGND VPWR VPWR sky130_fd_sc_hd__fill_2
XFILLER_13_259 VGND VGND VPWR VPWR sky130_fd_sc_hd__decap_3
Xclkbuf_2_1__f_i_clk clkbuf_0_i_clk/X VGND VGND VPWR VPWR clkload0/A sky130_fd_sc_hd__clkbuf_16
Xclkbuf_leaf_1_i_clk clkbuf_leaf_2_i_clk/A VGND VGND VPWR VPWR clkload3/A sky130_fd_sc_hd__clkbuf_8
XFILLER_21_292 VGND VGND VPWR VPWR sky130_fd_sc_hd__fill_1
XFILLER_0_141 VGND VGND VPWR VPWR sky130_fd_sc_hd__decap_3
XFILLER_0_185 VGND VGND VPWR VPWR sky130_fd_sc_hd__decap_3
XFILLER_36_307 VGND VGND VPWR VPWR sky130_fd_sc_hd__fill_1
XFILLER_48_156 VGND VGND VPWR VPWR sky130_fd_sc_hd__decap_3
XFILLER_48_189 VGND VGND VPWR VPWR sky130_fd_sc_hd__decap_3
XFILLER_44_80 VGND VGND VPWR VPWR sky130_fd_sc_hd__decap_3
X_0991_ _1061_/A1 _1061_/A2 _1040_/B1 VGND VGND VPWR VPWR _0991_/X sky130_fd_sc_hd__o21a_2
XFILLER_8_263 VGND VGND VPWR VPWR sky130_fd_sc_hd__decap_3
XFILLER_5_30 VGND VGND VPWR VPWR sky130_fd_sc_hd__fill_1
XFILLER_27_307 VGND VGND VPWR VPWR sky130_fd_sc_hd__fill_1
XTAP_TAPCELL_ROW_20_213 VGND VPWR sky130_fd_sc_hd__tapvpwrvgnd_1
Xhold230 _1272_/Q VGND VGND VPWR VPWR hold230/X sky130_fd_sc_hd__dlygate4sd3_1
Xhold241 _0965_/X VGND VGND VPWR VPWR _1269_/D sky130_fd_sc_hd__dlygate4sd3_1
Xhold252 _0763_/Y VGND VGND VPWR VPWR _1220_/D sky130_fd_sc_hd__dlygate4sd3_1
Xhold263 _1159_/Q VGND VGND VPWR VPWR _0895_/A sky130_fd_sc_hd__dlygate4sd3_1
Xhold285 _1226_/Q VGND VGND VPWR VPWR _0562_/A sky130_fd_sc_hd__dlygate4sd3_1
Xhold274 _1229_/Q VGND VGND VPWR VPWR _0734_/A sky130_fd_sc_hd__dlygate4sd3_1
XTAP_TAPCELL_ROW_51_371 VGND VPWR sky130_fd_sc_hd__tapvpwrvgnd_1
XTAP_TAPCELL_ROW_43_327 VGND VPWR sky130_fd_sc_hd__tapvpwrvgnd_1
Xinput9 i_clk_div_lsb[1] VGND VGND VPWR VPWR input9/X sky130_fd_sc_hd__clkdlybuf4s25_1
X_1190_ _1233_/CLK _1190_/D fanout119/X VGND VGND VPWR VPWR _1190_/Q sky130_fd_sc_hd__dfrtp_2
XFILLER_44_170 VGND VGND VPWR VPWR sky130_fd_sc_hd__decap_3
X_0974_ hold232/X _1273_/Q _0974_/S VGND VGND VPWR VPWR _0974_/X sky130_fd_sc_hd__mux2_1
XFILLER_42_129 VGND VGND VPWR VPWR sky130_fd_sc_hd__decap_3
XFILLER_50_162 VGND VGND VPWR VPWR sky130_fd_sc_hd__decap_3
XFILLER_50_195 VGND VGND VPWR VPWR sky130_fd_sc_hd__fill_1
XFILLER_51_26 VGND VGND VPWR VPWR sky130_fd_sc_hd__fill_2
XFILLER_25_60 VGND VGND VPWR VPWR sky130_fd_sc_hd__fill_2
XFILLER_41_140 VGND VGND VPWR VPWR sky130_fd_sc_hd__decap_3
XFILLER_41_70 VGND VGND VPWR VPWR sky130_fd_sc_hd__decap_3
X_0690_ _0690_/A _1072_/Q VGND VGND VPWR VPWR _0699_/A sky130_fd_sc_hd__xor2_2
XFILLER_49_240 VGND VGND VPWR VPWR sky130_fd_sc_hd__decap_3
XFILLER_49_273 VGND VGND VPWR VPWR sky130_fd_sc_hd__decap_3
XFILLER_49_284 VGND VGND VPWR VPWR sky130_fd_sc_hd__decap_3
X_1242_ clkload9/A _1242_/D _1050_/X VGND VGND VPWR VPWR _1242_/Q sky130_fd_sc_hd__dfrtp_2
X_1173_ _1192_/CLK _1173_/D load_slew115/X VGND VGND VPWR VPWR _1173_/Q sky130_fd_sc_hd__dfrtp_2
XPHY_EDGE_ROW_10_Right_10 VGND VGND VPWR VPWR sky130_fd_sc_hd__decap_3
XFILLER_24_129 VGND VGND VPWR VPWR sky130_fd_sc_hd__decap_3
XFILLER_32_162 VGND VGND VPWR VPWR sky130_fd_sc_hd__fill_1
X_0957_ _1159_/Q _1160_/Q VGND VGND VPWR VPWR _0957_/Y sky130_fd_sc_hd__nor2_2
X_0888_ _0575_/A hold159/X _0888_/S VGND VGND VPWR VPWR _1103_/D sky130_fd_sc_hd__mux2_1
XFILLER_46_26 VGND VGND VPWR VPWR sky130_fd_sc_hd__fill_2
XFILLER_46_232 VGND VGND VPWR VPWR sky130_fd_sc_hd__decap_3
XFILLER_14_173 VGND VGND VPWR VPWR sky130_fd_sc_hd__decap_3
XFILLER_36_70 VGND VGND VPWR VPWR sky130_fd_sc_hd__fill_1
XFILLER_46_287 VGND VGND VPWR VPWR sky130_fd_sc_hd__decap_3
Xinput34 i_slave_addr_reg[5] VGND VGND VPWR VPWR _0695_/A sky130_fd_sc_hd__clkdlybuf4s25_1
Xinput23 i_mode_reg[1] VGND VGND VPWR VPWR _0634_/A sky130_fd_sc_hd__clkdlybuf4s25_1
Xinput12 i_clk_div_lsb[4] VGND VGND VPWR VPWR _0623_/A sky130_fd_sc_hd__clkdlybuf4s25_1
X_0811_ _1244_/Q _0814_/C _0815_/A VGND VGND VPWR VPWR _0811_/Y sky130_fd_sc_hd__a21oi_2
X_0742_ _1128_/Q _1152_/Q _0741_/X VGND VGND VPWR VPWR _1200_/D sky130_fd_sc_hd__a21o_2
X_0673_ hold273/X _0545_/Y _1186_/D VGND VGND VPWR VPWR _1163_/D sky130_fd_sc_hd__a21o_2
XFILLER_16_29 VGND VGND VPWR VPWR sky130_fd_sc_hd__decap_3
XFILLER_37_254 VGND VGND VPWR VPWR sky130_fd_sc_hd__decap_3
X_1225_ _1226_/CLK _1225_/D _1033_/X VGND VGND VPWR VPWR _1225_/Q sky130_fd_sc_hd__dfrtp_2
X_1156_ clkload8/A _1156_/D _1004_/X VGND VGND VPWR VPWR _1156_/Q sky130_fd_sc_hd__dfstp_2
X_1087_ _1119_/CLK _1087_/D load_slew108/X VGND VGND VPWR VPWR _1087_/Q sky130_fd_sc_hd__dfrtp_2
XFILLER_20_187 VGND VGND VPWR VPWR sky130_fd_sc_hd__fill_2
XTAP_TAPCELL_ROW_7_147 VGND VPWR sky130_fd_sc_hd__tapvpwrvgnd_1
XFILLER_43_279 VGND VGND VPWR VPWR sky130_fd_sc_hd__fill_1
XFILLER_51_290 VGND VGND VPWR VPWR sky130_fd_sc_hd__decap_3
XFILLER_22_50 VGND VGND VPWR VPWR sky130_fd_sc_hd__decap_3
XFILLER_7_169 VGND VGND VPWR VPWR sky130_fd_sc_hd__fill_2
X_1010_ _1017_/A1 _1017_/A2 _1016_/B1 VGND VGND VPWR VPWR _1010_/X sky130_fd_sc_hd__o21a_2
XTAP_TAPCELL_ROW_12_171 VGND VPWR sky130_fd_sc_hd__tapvpwrvgnd_1
XFILLER_8_85 VGND VGND VPWR VPWR sky130_fd_sc_hd__fill_1
X_0725_ _0534_/Y _1207_/Q _1206_/Q _0535_/Y VGND VGND VPWR VPWR _0725_/X sky130_fd_sc_hd__o2bb2a_2
X_0656_ _1156_/Q hold176/X _0645_/A VGND VGND VPWR VPWR _1156_/D sky130_fd_sc_hd__o21a_2
X_1208_ _1211_/CLK _1208_/D _1016_/X VGND VGND VPWR VPWR _1208_/Q sky130_fd_sc_hd__dfrtp_2
X_0587_ _1138_/Q _1137_/Q _0592_/A _1211_/Q hold250/X VGND VGND VPWR VPWR _0588_/B
+ sky130_fd_sc_hd__a311o_2
XFILLER_40_227 VGND VGND VPWR VPWR sky130_fd_sc_hd__decap_3
XFILLER_43_38 VGND VGND VPWR VPWR sky130_fd_sc_hd__decap_3
X_1139_ clkload7/A _1139_/D _0987_/X VGND VGND VPWR VPWR _1139_/Q sky130_fd_sc_hd__dfrtp_2
XTAP_TAPCELL_ROW_35_285 VGND VPWR sky130_fd_sc_hd__tapvpwrvgnd_1
XFILLER_17_94 VGND VGND VPWR VPWR sky130_fd_sc_hd__decap_3
XFILLER_31_249 VGND VGND VPWR VPWR sky130_fd_sc_hd__decap_3
XFILLER_33_60 VGND VGND VPWR VPWR sky130_fd_sc_hd__fill_1
XTAP_TAPCELL_ROW_26_241 VGND VPWR sky130_fd_sc_hd__tapvpwrvgnd_1
XFILLER_39_305 VGND VGND VPWR VPWR sky130_fd_sc_hd__decap_3
XTAP_TAPCELL_ROW_49_355 VGND VPWR sky130_fd_sc_hd__tapvpwrvgnd_1
XFILLER_22_249 VGND VGND VPWR VPWR sky130_fd_sc_hd__decap_3
XPHY_EDGE_ROW_8_Right_8 VGND VGND VPWR VPWR sky130_fd_sc_hd__decap_3
X_0708_ _0708_/A _0708_/B _0708_/C VGND VGND VPWR VPWR _1229_/D sky130_fd_sc_hd__nor3_2
X_0639_ _1251_/Q _1144_/Q _1142_/Q VGND VGND VPWR VPWR _0639_/Y sky130_fd_sc_hd__a21oi_2
XPHY_EDGE_ROW_39_Right_39 VGND VGND VPWR VPWR sky130_fd_sc_hd__decap_3
XPHY_EDGE_ROW_48_Right_48 VGND VGND VPWR VPWR sky130_fd_sc_hd__decap_3
XFILLER_0_131 VGND VGND VPWR VPWR sky130_fd_sc_hd__fill_1
XFILLER_48_168 VGND VGND VPWR VPWR sky130_fd_sc_hd__decap_3
XFILLER_12_271 VGND VGND VPWR VPWR sky130_fd_sc_hd__decap_3
X_0990_ _1061_/A1 _1061_/A2 _1040_/B1 VGND VGND VPWR VPWR _0990_/X sky130_fd_sc_hd__o21a_2
XFILLER_8_220 VGND VGND VPWR VPWR sky130_fd_sc_hd__decap_3
XFILLER_47_190 VGND VGND VPWR VPWR sky130_fd_sc_hd__decap_3
XFILLER_24_29 VGND VGND VPWR VPWR sky130_fd_sc_hd__decap_3
Xhold220 _1128_/Q VGND VGND VPWR VPWR hold220/X sky130_fd_sc_hd__dlygate4sd3_1
Xhold231 _0968_/X VGND VGND VPWR VPWR _1272_/D sky130_fd_sc_hd__dlygate4sd3_1
Xhold242 _1235_/Q VGND VGND VPWR VPWR hold242/X sky130_fd_sc_hd__dlygate4sd3_1
Xhold253 _1228_/Q VGND VGND VPWR VPWR hold253/X sky130_fd_sc_hd__dlygate4sd3_1
Xhold286 _1167_/Q VGND VGND VPWR VPWR _0739_/S sky130_fd_sc_hd__dlygate4sd3_1
Xhold275 _0734_/X VGND VGND VPWR VPWR _1231_/D sky130_fd_sc_hd__dlygate4sd3_1
Xhold264 _1085_/Q VGND VGND VPWR VPWR hold264/X sky130_fd_sc_hd__dlygate4sd3_1
XFILLER_45_116 VGND VGND VPWR VPWR sky130_fd_sc_hd__fill_1
XTAP_TAPCELL_ROW_43_328 VGND VPWR sky130_fd_sc_hd__tapvpwrvgnd_1
XFILLER_14_62 VGND VGND VPWR VPWR sky130_fd_sc_hd__decap_3
XTAP_TAPCELL_ROW_51_372 VGND VPWR sky130_fd_sc_hd__tapvpwrvgnd_1
XFILLER_36_116 VGND VGND VPWR VPWR sky130_fd_sc_hd__decap_3
XFILLER_36_138 VGND VGND VPWR VPWR sky130_fd_sc_hd__fill_2
XFILLER_51_119 VGND VGND VPWR VPWR sky130_fd_sc_hd__decap_3
X_0973_ hold226/X hold230/X _0974_/S VGND VGND VPWR VPWR _1277_/D sky130_fd_sc_hd__mux2_1
Xclkbuf_leaf_0_i_clk clkbuf_leaf_2_i_clk/A VGND VGND VPWR VPWR _1278_/CLK sky130_fd_sc_hd__clkbuf_8
XFILLER_23_300 VGND VGND VPWR VPWR sky130_fd_sc_hd__decap_3
XFILLER_42_108 VGND VGND VPWR VPWR sky130_fd_sc_hd__decap_3
XFILLER_50_141 VGND VGND VPWR VPWR sky130_fd_sc_hd__decap_3
XFILLER_50_174 VGND VGND VPWR VPWR sky130_fd_sc_hd__decap_3
XFILLER_51_49 VGND VGND VPWR VPWR sky130_fd_sc_hd__decap_3
XTAP_TAPCELL_ROW_40_309 VGND VPWR sky130_fd_sc_hd__tapvpwrvgnd_1
XFILLER_41_163 VGND VGND VPWR VPWR sky130_fd_sc_hd__decap_3
XFILLER_37_6 VGND VGND VPWR VPWR sky130_fd_sc_hd__fill_1
X_1241_ clkload9/A _1241_/D _1049_/X VGND VGND VPWR VPWR _1241_/Q sky130_fd_sc_hd__dfrtp_2
XFILLER_24_108 VGND VGND VPWR VPWR sky130_fd_sc_hd__decap_3
XFILLER_49_252 VGND VGND VPWR VPWR sky130_fd_sc_hd__decap_3
XFILLER_49_296 VGND VGND VPWR VPWR sky130_fd_sc_hd__decap_3
X_1172_ _1212_/CLK _1172_/D fanout105/X VGND VGND VPWR VPWR _1172_/Q sky130_fd_sc_hd__dfrtp_2
XFILLER_32_174 VGND VGND VPWR VPWR sky130_fd_sc_hd__decap_3
X_0956_ _0956_/A _0956_/B _0956_/C VGND VGND VPWR VPWR _1127_/D sky130_fd_sc_hd__and3_2
X_0887_ _0891_/A _1268_/Q VGND VGND VPWR VPWR _0888_/S sky130_fd_sc_hd__nand2_2
XFILLER_23_130 VGND VGND VPWR VPWR sky130_fd_sc_hd__decap_3
XFILLER_7_307 VGND VGND VPWR VPWR sky130_fd_sc_hd__fill_1
XFILLER_11_74 VGND VGND VPWR VPWR sky130_fd_sc_hd__decap_3
XFILLER_2_3 VGND VGND VPWR VPWR sky130_fd_sc_hd__decap_3
XFILLER_36_82 VGND VGND VPWR VPWR sky130_fd_sc_hd__fill_2
XFILLER_46_200 VGND VGND VPWR VPWR sky130_fd_sc_hd__decap_3
XFILLER_46_244 VGND VGND VPWR VPWR sky130_fd_sc_hd__decap_3
XFILLER_46_299 VGND VGND VPWR VPWR sky130_fd_sc_hd__decap_3
Xinput13 i_clk_div_lsb[5] VGND VGND VPWR VPWR input13/X sky130_fd_sc_hd__clkdlybuf4s25_1
X_0810_ _0815_/A _0810_/B _0814_/C VGND VGND VPWR VPWR _1243_/D sky130_fd_sc_hd__nor3_2
Xinput35 i_slave_addr_reg[6] VGND VGND VPWR VPWR _0689_/A sky130_fd_sc_hd__clkdlybuf4s25_1
Xinput24 i_mode_reg[3] VGND VGND VPWR VPWR input24/X sky130_fd_sc_hd__clkdlybuf4s25_1
X_0741_ _1153_/Q _1155_/Q _1129_/Q _0548_/Y VGND VGND VPWR VPWR _0741_/X sky130_fd_sc_hd__o211a_2
X_0672_ _1197_/Q _0680_/A _0672_/C VGND VGND VPWR VPWR _1186_/D sky130_fd_sc_hd__and3_2
XFILLER_35_3 VGND VGND VPWR VPWR sky130_fd_sc_hd__decap_3
XFILLER_37_233 VGND VGND VPWR VPWR sky130_fd_sc_hd__decap_3
X_1224_ _1262_/CLK _1224_/D _1032_/X VGND VGND VPWR VPWR _1224_/Q sky130_fd_sc_hd__dfrtp_2
X_1155_ clkload7/A _1155_/D _1003_/X VGND VGND VPWR VPWR _1155_/Q sky130_fd_sc_hd__dfrtp_2
X_1086_ _1278_/CLK _1086_/D load_slew99/X VGND VGND VPWR VPWR _1086_/Q sky130_fd_sc_hd__dfrtp_2
XFILLER_20_100 VGND VGND VPWR VPWR sky130_fd_sc_hd__decap_3
X_0939_ _1193_/Q _1186_/Q _1120_/Q _1121_/Q _1122_/Q VGND VGND VPWR VPWR _0949_/D
+ sky130_fd_sc_hd__o2111a_2
XTAP_TAPCELL_ROW_7_148 VGND VPWR sky130_fd_sc_hd__tapvpwrvgnd_1
XFILLER_43_225 VGND VGND VPWR VPWR sky130_fd_sc_hd__decap_3
XFILLER_11_100 VGND VGND VPWR VPWR sky130_fd_sc_hd__decap_3
XFILLER_19_266 VGND VGND VPWR VPWR sky130_fd_sc_hd__decap_3
XTAP_TAPCELL_ROW_12_172 VGND VPWR sky130_fd_sc_hd__tapvpwrvgnd_1
X_0724_ _0537_/Y _1204_/Q _0568_/Y _1138_/Q _0721_/X VGND VGND VPWR VPWR _0724_/X
+ sky130_fd_sc_hd__a221o_2
X_0655_ _1158_/D _0655_/B VGND VGND VPWR VPWR _1157_/D sky130_fd_sc_hd__nor2_2
X_0586_ _1137_/Q _0592_/A _1138_/Q VGND VGND VPWR VPWR _0588_/A sky130_fd_sc_hd__a21oi_2
X_1207_ _1211_/CLK _1207_/D _1015_/X VGND VGND VPWR VPWR _1207_/Q sky130_fd_sc_hd__dfrtp_2
XTAP_TAPCELL_ROW_4_129 VGND VPWR sky130_fd_sc_hd__tapvpwrvgnd_1
XFILLER_25_225 VGND VGND VPWR VPWR sky130_fd_sc_hd__decap_3
XFILLER_40_206 VGND VGND VPWR VPWR sky130_fd_sc_hd__decap_3
X_1138_ clkload7/A _1138_/D _0986_/X VGND VGND VPWR VPWR _1138_/Q sky130_fd_sc_hd__dfrtp_2
X_1069_ _1240_/CLK _1069_/D _0976_/X VGND VGND VPWR VPWR _1069_/Q sky130_fd_sc_hd__dfstp_2
XTAP_TAPCELL_ROW_35_286 VGND VPWR sky130_fd_sc_hd__tapvpwrvgnd_1
XFILLER_4_129 VGND VGND VPWR VPWR sky130_fd_sc_hd__decap_3
XFILLER_17_51 VGND VGND VPWR VPWR sky130_fd_sc_hd__decap_3
XTAP_TAPCELL_ROW_26_242 VGND VPWR sky130_fd_sc_hd__tapvpwrvgnd_1
XTAP_TAPCELL_ROW_49_356 VGND VPWR sky130_fd_sc_hd__tapvpwrvgnd_1
XFILLER_15_291 VGND VGND VPWR VPWR sky130_fd_sc_hd__decap_3
XFILLER_30_250 VGND VGND VPWR VPWR sky130_fd_sc_hd__fill_2
X_0707_ _0707_/A _0707_/B VGND VGND VPWR VPWR _0708_/C sky130_fd_sc_hd__or2_2
X_0638_ _0648_/A _0731_/A _0637_/Y _1142_/Q hold157/X VGND VGND VPWR VPWR _1143_/D
+ sky130_fd_sc_hd__a32o_2
X_0569_ _0569_/A VGND VGND VPWR VPWR _1068_/D sky130_fd_sc_hd__inv_2
XTAP_TAPCELL_ROW_0_110 VGND VPWR sky130_fd_sc_hd__tapvpwrvgnd_1
XFILLER_13_228 VGND VGND VPWR VPWR sky130_fd_sc_hd__decap_3
XFILLER_21_272 VGND VGND VPWR VPWR sky130_fd_sc_hd__fill_2
XFILLER_48_136 VGND VGND VPWR VPWR sky130_fd_sc_hd__decap_3
XFILLER_48_147 VGND VGND VPWR VPWR sky130_fd_sc_hd__decap_3
XFILLER_50_301 VGND VGND VPWR VPWR sky130_fd_sc_hd__decap_3
Xhold210 _1164_/Q VGND VGND VPWR VPWR _0737_/S sky130_fd_sc_hd__dlygate4sd3_1
Xhold221 _1155_/Q VGND VGND VPWR VPWR hold221/X sky130_fd_sc_hd__dlygate4sd3_1
Xhold232 _1278_/Q VGND VGND VPWR VPWR hold232/X sky130_fd_sc_hd__dlygate4sd3_1
Xhold243 _1267_/Q VGND VGND VPWR VPWR hold243/X sky130_fd_sc_hd__dlygate4sd3_1
Xhold254 _1075_/Q VGND VGND VPWR VPWR hold254/X sky130_fd_sc_hd__dlygate4sd3_1
Xhold287 _1143_/Q VGND VGND VPWR VPWR _0611_/B sky130_fd_sc_hd__dlygate4sd3_1
Xhold276 _1072_/Q VGND VGND VPWR VPWR hold276/X sky130_fd_sc_hd__dlygate4sd3_1
Xhold265 _1166_/Q VGND VGND VPWR VPWR hold265/X sky130_fd_sc_hd__dlygate4sd3_1
XFILLER_45_106 VGND VGND VPWR VPWR sky130_fd_sc_hd__decap_3
XFILLER_14_52 VGND VGND VPWR VPWR sky130_fd_sc_hd__fill_2
XFILLER_14_85 VGND VGND VPWR VPWR sky130_fd_sc_hd__decap_3
XFILLER_30_40 VGND VGND VPWR VPWR sky130_fd_sc_hd__fill_2
XTAP_TAPCELL_ROW_51_373 VGND VPWR sky130_fd_sc_hd__tapvpwrvgnd_1
XFILLER_30_51 VGND VGND VPWR VPWR sky130_fd_sc_hd__decap_3
XFILLER_39_60 VGND VGND VPWR VPWR sky130_fd_sc_hd__fill_2
XFILLER_51_109 VGND VGND VPWR VPWR sky130_fd_sc_hd__decap_3
Xi2c_master_controller_top_131 VGND VGND VPWR VPWR i2c_master_controller_top_131/HI
+ o_cmd_status_reg[1] sky130_fd_sc_hd__conb_1
XFILLER_44_194 VGND VGND VPWR VPWR sky130_fd_sc_hd__fill_2
X_0972_ hold247/X hold218/X _0974_/S VGND VGND VPWR VPWR _1276_/D sky130_fd_sc_hd__mux2_1
XFILLER_19_19 VGND VGND VPWR VPWR sky130_fd_sc_hd__decap_3
XFILLER_27_106 VGND VGND VPWR VPWR sky130_fd_sc_hd__decap_3
XFILLER_35_172 VGND VGND VPWR VPWR sky130_fd_sc_hd__decap_3
XFILLER_50_153 VGND VGND VPWR VPWR sky130_fd_sc_hd__decap_3
XFILLER_50_186 VGND VGND VPWR VPWR sky130_fd_sc_hd__decap_3
XFILLER_50_197 VGND VGND VPWR VPWR sky130_fd_sc_hd__decap_3
XFILLER_51_17 VGND VGND VPWR VPWR sky130_fd_sc_hd__decap_3
XFILLER_41_94 VGND VGND VPWR VPWR sky130_fd_sc_hd__decap_3
XFILLER_49_220 VGND VGND VPWR VPWR sky130_fd_sc_hd__decap_3
XFILLER_49_231 VGND VGND VPWR VPWR sky130_fd_sc_hd__decap_3
XFILLER_49_264 VGND VGND VPWR VPWR sky130_fd_sc_hd__decap_3
X_1240_ _1240_/CLK _1240_/D _1048_/X VGND VGND VPWR VPWR _1240_/Q sky130_fd_sc_hd__dfrtp_2
X_1171_ _1212_/CLK _1171_/D _1020_/B1 VGND VGND VPWR VPWR _1171_/Q sky130_fd_sc_hd__dfstp_2
XFILLER_32_197 VGND VGND VPWR VPWR sky130_fd_sc_hd__decap_3
X_0955_ _1126_/Q _1127_/Q _0955_/C VGND VGND VPWR VPWR _0956_/C sky130_fd_sc_hd__nand3_2
X_0886_ _0575_/A hold162/X _0886_/S VGND VGND VPWR VPWR _1102_/D sky130_fd_sc_hd__mux2_1
XFILLER_23_164 VGND VGND VPWR VPWR sky130_fd_sc_hd__decap_3
XFILLER_11_97 VGND VGND VPWR VPWR sky130_fd_sc_hd__decap_3
XFILLER_46_212 VGND VGND VPWR VPWR sky130_fd_sc_hd__fill_1
XFILLER_46_223 VGND VGND VPWR VPWR sky130_fd_sc_hd__decap_3
XFILLER_46_256 VGND VGND VPWR VPWR sky130_fd_sc_hd__fill_2
XFILLER_14_164 VGND VGND VPWR VPWR sky130_fd_sc_hd__decap_3
XFILLER_14_197 VGND VGND VPWR VPWR sky130_fd_sc_hd__fill_1
Xinput36 i_transmit_data[0] VGND VGND VPWR VPWR input36/X sky130_fd_sc_hd__clkdlybuf4s25_1
Xinput25 i_mode_reg[5] VGND VGND VPWR VPWR input25/X sky130_fd_sc_hd__clkdlybuf4s25_1
Xinput14 i_clk_div_lsb[6] VGND VGND VPWR VPWR _0628_/A sky130_fd_sc_hd__clkdlybuf4s25_1
X_0740_ hold211/X _0548_/Y _1154_/D VGND VGND VPWR VPWR _0740_/Y sky130_fd_sc_hd__o21ai_2
XPHY_EDGE_ROW_26_Left_78 VGND VGND VPWR VPWR sky130_fd_sc_hd__decap_3
X_0671_ _0617_/B _0678_/B _0662_/D _1163_/Q VGND VGND VPWR VPWR _0672_/C sky130_fd_sc_hd__a31o_2
XFILLER_28_3 VGND VGND VPWR VPWR sky130_fd_sc_hd__decap_3
XFILLER_37_223 VGND VGND VPWR VPWR sky130_fd_sc_hd__fill_1
XFILLER_37_245 VGND VGND VPWR VPWR sky130_fd_sc_hd__decap_3
X_1223_ _1262_/CLK _1223_/D _1031_/X VGND VGND VPWR VPWR _1223_/Q sky130_fd_sc_hd__dfrtp_2
X_1154_ _1259_/CLK _1154_/D _1002_/X VGND VGND VPWR VPWR _1154_/Q sky130_fd_sc_hd__dfrtp_2
X_1085_ _1119_/CLK _1085_/D load_slew108/X VGND VGND VPWR VPWR _1085_/Q sky130_fd_sc_hd__dfrtp_2
XFILLER_20_134 VGND VGND VPWR VPWR sky130_fd_sc_hd__decap_3
X_0938_ _0940_/B _0956_/A _0938_/C VGND VGND VPWR VPWR _1121_/D sky130_fd_sc_hd__and3b_2
X_0869_ _1175_/Q _1109_/Q VGND VGND VPWR VPWR _0869_/X sky130_fd_sc_hd__and2b_2
XFILLER_28_245 VGND VGND VPWR VPWR sky130_fd_sc_hd__decap_3
XFILLER_28_256 VGND VGND VPWR VPWR sky130_fd_sc_hd__decap_3
XFILLER_11_156 VGND VGND VPWR VPWR sky130_fd_sc_hd__decap_3
XFILLER_51_281 VGND VGND VPWR VPWR sky130_fd_sc_hd__decap_3
XFILLER_7_116 VGND VGND VPWR VPWR sky130_fd_sc_hd__decap_3
XFILLER_22_85 VGND VGND VPWR VPWR sky130_fd_sc_hd__decap_3
XFILLER_7_149 VGND VGND VPWR VPWR sky130_fd_sc_hd__decap_3
XFILLER_19_223 VGND VGND VPWR VPWR sky130_fd_sc_hd__fill_1
XFILLER_34_226 VGND VGND VPWR VPWR sky130_fd_sc_hd__fill_2
XFILLER_34_259 VGND VGND VPWR VPWR sky130_fd_sc_hd__decap_3
X_0723_ _0537_/Y _1204_/Q _0568_/Y _1138_/Q _0719_/Y VGND VGND VPWR VPWR _0728_/B
+ sky130_fd_sc_hd__o221a_2
XTAP_TAPCELL_ROW_12_173 VGND VPWR sky130_fd_sc_hd__tapvpwrvgnd_1
XFILLER_8_21 VGND VGND VPWR VPWR sky130_fd_sc_hd__fill_2
X_0654_ _1129_/Q hold176/X _1199_/D VGND VGND VPWR VPWR _0655_/B sky130_fd_sc_hd__a21oi_2
X_0585_ _0585_/A _0600_/B _0585_/C VGND VGND VPWR VPWR _1139_/D sky130_fd_sc_hd__and3_2
X_1206_ _1211_/CLK _1206_/D _1014_/X VGND VGND VPWR VPWR _1206_/Q sky130_fd_sc_hd__dfrtp_2
X_1137_ clkload7/A _1137_/D _0985_/X VGND VGND VPWR VPWR _1137_/Q sky130_fd_sc_hd__dfrtp_2
XFILLER_33_292 VGND VGND VPWR VPWR sky130_fd_sc_hd__fill_1
XFILLER_40_218 VGND VGND VPWR VPWR sky130_fd_sc_hd__decap_3
XFILLER_43_29 VGND VGND VPWR VPWR sky130_fd_sc_hd__decap_3
X_1068_ _1240_/CLK _1068_/D _0840_/X VGND VGND VPWR VPWR _1068_/Q sky130_fd_sc_hd__dfstp_2
XTAP_TAPCELL_ROW_35_287 VGND VPWR sky130_fd_sc_hd__tapvpwrvgnd_1
XFILLER_0_303 VGND VGND VPWR VPWR sky130_fd_sc_hd__decap_3
XFILLER_48_307 VGND VGND VPWR VPWR sky130_fd_sc_hd__fill_1
XFILLER_17_63 VGND VGND VPWR VPWR sky130_fd_sc_hd__decap_3
XFILLER_17_85 VGND VGND VPWR VPWR sky130_fd_sc_hd__decap_3
XFILLER_24_270 VGND VGND VPWR VPWR sky130_fd_sc_hd__decap_3
XFILLER_31_218 VGND VGND VPWR VPWR sky130_fd_sc_hd__decap_3
XTAP_TAPCELL_ROW_26_243 VGND VPWR sky130_fd_sc_hd__tapvpwrvgnd_1
XFILLER_33_51 VGND VGND VPWR VPWR sky130_fd_sc_hd__decap_3
XFILLER_12_6 VGND VGND VPWR VPWR sky130_fd_sc_hd__decap_3
XTAP_TAPCELL_ROW_49_357 VGND VPWR sky130_fd_sc_hd__tapvpwrvgnd_1
X_0706_ _1222_/Q _1221_/Q _1224_/Q _1223_/Q VGND VGND VPWR VPWR _0707_/B sky130_fd_sc_hd__or4_2
XPHY_EDGE_ROW_29_Left_81 VGND VGND VPWR VPWR sky130_fd_sc_hd__decap_3
X_0637_ _1251_/Q _1144_/Q VGND VGND VPWR VPWR _0637_/Y sky130_fd_sc_hd__nand2_2
X_0568_ _1208_/Q VGND VGND VPWR VPWR _0568_/Y sky130_fd_sc_hd__inv_2
XPHY_EDGE_ROW_13_Left_65 VGND VGND VPWR VPWR sky130_fd_sc_hd__decap_3
XTAP_TAPCELL_ROW_0_111 VGND VPWR sky130_fd_sc_hd__tapvpwrvgnd_1
XTAP_TAPCELL_ROW_23_224 VGND VPWR sky130_fd_sc_hd__tapvpwrvgnd_1
XFILLER_0_144 VGND VGND VPWR VPWR sky130_fd_sc_hd__fill_1
XFILLER_0_166 VGND VGND VPWR VPWR sky130_fd_sc_hd__fill_2
XFILLER_48_159 VGND VGND VPWR VPWR sky130_fd_sc_hd__decap_3
XFILLER_12_262 VGND VGND VPWR VPWR sky130_fd_sc_hd__decap_3
XFILLER_44_83 VGND VGND VPWR VPWR sky130_fd_sc_hd__fill_1
XFILLER_8_266 VGND VGND VPWR VPWR sky130_fd_sc_hd__decap_3
XFILLER_10_3 VGND VGND VPWR VPWR sky130_fd_sc_hd__decap_3
XFILLER_47_181 VGND VGND VPWR VPWR sky130_fd_sc_hd__decap_3
Xhold200 _0684_/X VGND VGND VPWR VPWR _1172_/D sky130_fd_sc_hd__dlygate4sd3_1
Xhold211 _1128_/Q VGND VGND VPWR VPWR hold211/X sky130_fd_sc_hd__dlygate4sd3_1
Xhold222 _1234_/Q VGND VGND VPWR VPWR hold222/X sky130_fd_sc_hd__dlygate4sd3_1
Xhold233 _0974_/X VGND VGND VPWR VPWR _1278_/D sky130_fd_sc_hd__dlygate4sd3_1
Xhold244 _1263_/Q VGND VGND VPWR VPWR hold244/X sky130_fd_sc_hd__dlygate4sd3_1
Xhold255 _1076_/Q VGND VGND VPWR VPWR hold255/X sky130_fd_sc_hd__dlygate4sd3_1
Xhold288 _1159_/Q VGND VGND VPWR VPWR hold288/X sky130_fd_sc_hd__dlygate4sd3_1
Xhold277 _1073_/Q VGND VGND VPWR VPWR hold277/X sky130_fd_sc_hd__dlygate4sd3_1
Xhold266 _1070_/Q VGND VGND VPWR VPWR hold266/X sky130_fd_sc_hd__dlygate4sd3_1
XFILLER_38_181 VGND VGND VPWR VPWR sky130_fd_sc_hd__decap_3
XFILLER_38_192 VGND VGND VPWR VPWR sky130_fd_sc_hd__decap_3
XFILLER_41_302 VGND VGND VPWR VPWR sky130_fd_sc_hd__decap_3
XFILLER_5_203 VGND VGND VPWR VPWR sky130_fd_sc_hd__fill_2
XFILLER_30_85 VGND VGND VPWR VPWR sky130_fd_sc_hd__fill_1
X_0971_ hold213/X hold226/X _0974_/S VGND VGND VPWR VPWR _1275_/D sky130_fd_sc_hd__mux2_1
XFILLER_35_140 VGND VGND VPWR VPWR sky130_fd_sc_hd__fill_1
XFILLER_50_165 VGND VGND VPWR VPWR sky130_fd_sc_hd__decap_3
XFILLER_51_29 VGND VGND VPWR VPWR sky130_fd_sc_hd__fill_2
XFILLER_26_195 VGND VGND VPWR VPWR sky130_fd_sc_hd__fill_1
XFILLER_41_154 VGND VGND VPWR VPWR sky130_fd_sc_hd__decap_3
XFILLER_49_243 VGND VGND VPWR VPWR sky130_fd_sc_hd__decap_3
XFILLER_49_276 VGND VGND VPWR VPWR sky130_fd_sc_hd__decap_3
XFILLER_49_287 VGND VGND VPWR VPWR sky130_fd_sc_hd__decap_3
X_1170_ clkload4/A _1170_/D fanout105/X VGND VGND VPWR VPWR _1170_/Q sky130_fd_sc_hd__dfrtp_2
X_0954_ _1126_/Q _0955_/C _1127_/Q VGND VGND VPWR VPWR _0956_/B sky130_fd_sc_hd__a21o_2
X_0885_ _0891_/A _1265_/Q VGND VGND VPWR VPWR _0886_/S sky130_fd_sc_hd__nand2_2
XFILLER_46_29 VGND VGND VPWR VPWR sky130_fd_sc_hd__fill_2
XFILLER_11_305 VGND VGND VPWR VPWR sky130_fd_sc_hd__decap_3
XFILLER_23_121 VGND VGND VPWR VPWR sky130_fd_sc_hd__decap_3
XFILLER_23_198 VGND VGND VPWR VPWR sky130_fd_sc_hd__fill_2
XFILLER_46_235 VGND VGND VPWR VPWR sky130_fd_sc_hd__decap_3
XPHY_EDGE_ROW_1_Left_53 VGND VGND VPWR VPWR sky130_fd_sc_hd__decap_3
XFILLER_14_176 VGND VGND VPWR VPWR sky130_fd_sc_hd__fill_1
Xinput37 i_transmit_data[1] VGND VGND VPWR VPWR input37/X sky130_fd_sc_hd__clkdlybuf4s25_1
Xinput26 i_mode_reg[6] VGND VGND VPWR VPWR input26/X sky130_fd_sc_hd__clkdlybuf4s25_1
Xinput15 i_clk_div_lsb[7] VGND VGND VPWR VPWR _0628_/B sky130_fd_sc_hd__clkdlybuf4s25_1
X_0670_ _1159_/Q hold289/X _0737_/S _0556_/Y VGND VGND VPWR VPWR _1164_/D sky130_fd_sc_hd__a22o_2
XFILLER_37_257 VGND VGND VPWR VPWR sky130_fd_sc_hd__decap_3
XFILLER_37_279 VGND VGND VPWR VPWR sky130_fd_sc_hd__fill_1
X_1222_ _1262_/CLK _1222_/D _1030_/X VGND VGND VPWR VPWR _1222_/Q sky130_fd_sc_hd__dfrtp_2
X_1153_ _1259_/CLK _1153_/D _1001_/X VGND VGND VPWR VPWR _1153_/Q sky130_fd_sc_hd__dfrtp_2
X_1084_ clkload3/A _1084_/D load_slew99/X VGND VGND VPWR VPWR _1084_/Q sky130_fd_sc_hd__dfrtp_2
X_0937_ _1120_/Q _1121_/Q _0937_/C VGND VGND VPWR VPWR _0940_/B sky130_fd_sc_hd__and3_2
X_0868_ hold216/X _0867_/X _0862_/Y VGND VGND VPWR VPWR _1092_/D sky130_fd_sc_hd__o21a_2
X_0799_ _0804_/A _0799_/B _0799_/C VGND VGND VPWR VPWR _1239_/D sky130_fd_sc_hd__and3_2
XFILLER_9_191 VGND VGND VPWR VPWR sky130_fd_sc_hd__fill_1
XPHY_EDGE_ROW_43_Left_95 VGND VGND VPWR VPWR sky130_fd_sc_hd__decap_3
XFILLER_11_113 VGND VGND VPWR VPWR sky130_fd_sc_hd__decap_3
XFILLER_22_53 VGND VGND VPWR VPWR sky130_fd_sc_hd__decap_3
XFILLER_51_271 VGND VGND VPWR VPWR sky130_fd_sc_hd__decap_3
XFILLER_51_293 VGND VGND VPWR VPWR sky130_fd_sc_hd__decap_3
XFILLER_6_150 VGND VGND VPWR VPWR sky130_fd_sc_hd__decap_3
X_0722_ _1132_/Q _1202_/Q VGND VGND VPWR VPWR _0728_/A sky130_fd_sc_hd__xnor2_2
X_0653_ _1129_/Q _1156_/Q VGND VGND VPWR VPWR _1158_/D sky130_fd_sc_hd__and2_2
XFILLER_40_3 VGND VGND VPWR VPWR sky130_fd_sc_hd__fill_2
X_0584_ _1139_/Q _1138_/Q _1137_/Q _0592_/A VGND VGND VPWR VPWR _0585_/C sky130_fd_sc_hd__nand4_2
XFILLER_25_216 VGND VGND VPWR VPWR sky130_fd_sc_hd__fill_1
X_1205_ _1211_/CLK _1205_/D _1013_/X VGND VGND VPWR VPWR _1205_/Q sky130_fd_sc_hd__dfrtp_2
X_1136_ clkload7/A _1136_/D _0984_/X VGND VGND VPWR VPWR _1136_/Q sky130_fd_sc_hd__dfrtp_2
X_1067_ _1067_/A1 _1067_/A2 _1067_/B1 VGND VGND VPWR VPWR _1067_/X sky130_fd_sc_hd__o21a_2
XTAP_TAPCELL_ROW_35_288 VGND VPWR sky130_fd_sc_hd__tapvpwrvgnd_1
XFILLER_17_97 VGND VGND VPWR VPWR sky130_fd_sc_hd__fill_1
XTAP_TAPCELL_ROW_49_358 VGND VPWR sky130_fd_sc_hd__tapvpwrvgnd_1
XTAP_TAPCELL_ROW_32_269 VGND VPWR sky130_fd_sc_hd__tapvpwrvgnd_1
X_0705_ _1226_/Q _1225_/Q _1228_/Q _1227_/Q VGND VGND VPWR VPWR _0707_/A sky130_fd_sc_hd__or4_2
X_0636_ _1189_/Q _1142_/Q _1253_/D _0635_/X VGND VGND VPWR VPWR _1144_/D sky130_fd_sc_hd__o2bb2a_2
X_0567_ _0567_/A VGND VGND VPWR VPWR _0567_/Y sky130_fd_sc_hd__inv_2
X_1119_ _1119_/CLK _1119_/D _1020_/B1 VGND VGND VPWR VPWR _1119_/Q sky130_fd_sc_hd__dfrtp_2
XTAP_TAPCELL_ROW_23_225 VGND VPWR sky130_fd_sc_hd__tapvpwrvgnd_1
XTAP_TAPCELL_ROW_0_112 VGND VPWR sky130_fd_sc_hd__tapvpwrvgnd_1
XPHY_EDGE_ROW_17_Right_17 VGND VGND VPWR VPWR sky130_fd_sc_hd__decap_3
XPHY_EDGE_ROW_26_Right_26 VGND VGND VPWR VPWR sky130_fd_sc_hd__decap_3
XFILLER_28_85 VGND VGND VPWR VPWR sky130_fd_sc_hd__decap_3
XTAP_TAPCELL_ROW_46_339 VGND VPWR sky130_fd_sc_hd__tapvpwrvgnd_1
XPHY_EDGE_ROW_35_Right_35 VGND VGND VPWR VPWR sky130_fd_sc_hd__decap_3
XFILLER_8_223 VGND VGND VPWR VPWR sky130_fd_sc_hd__decap_3
XPHY_EDGE_ROW_30_Left_82 VGND VGND VPWR VPWR sky130_fd_sc_hd__decap_3
XPHY_EDGE_ROW_44_Right_44 VGND VGND VPWR VPWR sky130_fd_sc_hd__decap_3
XFILLER_47_193 VGND VGND VPWR VPWR sky130_fd_sc_hd__decap_3
Xhold201 _1113_/Q VGND VGND VPWR VPWR hold201/X sky130_fd_sc_hd__dlygate4sd3_1
Xhold212 _0740_/Y VGND VGND VPWR VPWR _1210_/D sky130_fd_sc_hd__dlygate4sd3_1
Xhold223 _1188_/Q VGND VGND VPWR VPWR hold223/X sky130_fd_sc_hd__dlygate4sd3_1
Xhold234 _1110_/Q VGND VGND VPWR VPWR hold234/X sky130_fd_sc_hd__dlygate4sd3_1
Xhold245 _0959_/X VGND VGND VPWR VPWR _1263_/D sky130_fd_sc_hd__dlygate4sd3_1
Xhold256 _1174_/Q VGND VGND VPWR VPWR _0733_/B sky130_fd_sc_hd__dlygate4sd3_1
Xhold289 _1185_/Q VGND VGND VPWR VPWR hold289/X sky130_fd_sc_hd__dlygate4sd3_1
Xhold278 _1153_/Q VGND VGND VPWR VPWR hold278/X sky130_fd_sc_hd__dlygate4sd3_1
Xhold267 _1071_/Q VGND VGND VPWR VPWR hold267/X sky130_fd_sc_hd__dlygate4sd3_1
X_0619_ input9/X _0621_/A VGND VGND VPWR VPWR _1202_/D sky130_fd_sc_hd__xor2_2
XFILLER_14_65 VGND VGND VPWR VPWR sky130_fd_sc_hd__decap_3
XTAP_TAPCELL_ROW_51_364 VGND VPWR sky130_fd_sc_hd__tapvpwrvgnd_1
XFILLER_30_97 VGND VGND VPWR VPWR sky130_fd_sc_hd__decap_3
XFILLER_17_300 VGND VGND VPWR VPWR sky130_fd_sc_hd__decap_3
XTAP_TAPCELL_ROW_42_320 VGND VPWR sky130_fd_sc_hd__tapvpwrvgnd_1
X_0970_ _0615_/A hold213/X _0970_/S VGND VGND VPWR VPWR _1274_/D sky130_fd_sc_hd__mux2_1
XFILLER_23_303 VGND VGND VPWR VPWR sky130_fd_sc_hd__decap_3
XFILLER_35_163 VGND VGND VPWR VPWR sky130_fd_sc_hd__decap_3
XFILLER_50_100 VGND VGND VPWR VPWR sky130_fd_sc_hd__decap_3
XFILLER_50_133 VGND VGND VPWR VPWR sky130_fd_sc_hd__decap_3
XFILLER_50_144 VGND VGND VPWR VPWR sky130_fd_sc_hd__decap_3
XFILLER_50_177 VGND VGND VPWR VPWR sky130_fd_sc_hd__decap_3
XFILLER_26_130 VGND VGND VPWR VPWR sky130_fd_sc_hd__fill_2
XFILLER_26_141 VGND VGND VPWR VPWR sky130_fd_sc_hd__fill_1
XFILLER_41_100 VGND VGND VPWR VPWR sky130_fd_sc_hd__decap_3
XFILLER_41_122 VGND VGND VPWR VPWR sky130_fd_sc_hd__fill_1
XFILLER_41_166 VGND VGND VPWR VPWR sky130_fd_sc_hd__fill_2
XFILLER_41_177 VGND VGND VPWR VPWR sky130_fd_sc_hd__decap_3
XFILLER_49_211 VGND VGND VPWR VPWR sky130_fd_sc_hd__decap_3
XFILLER_49_255 VGND VGND VPWR VPWR sky130_fd_sc_hd__decap_3
XFILLER_49_299 VGND VGND VPWR VPWR sky130_fd_sc_hd__decap_3
XFILLER_32_177 VGND VGND VPWR VPWR sky130_fd_sc_hd__decap_3
X_0953_ _0956_/A _0953_/B _0953_/C VGND VGND VPWR VPWR _1126_/D sky130_fd_sc_hd__and3_2
X_0884_ _0575_/A hold164/X _0884_/S VGND VGND VPWR VPWR _1101_/D sky130_fd_sc_hd__mux2_1
XFILLER_23_100 VGND VGND VPWR VPWR sky130_fd_sc_hd__decap_3
XFILLER_23_133 VGND VGND VPWR VPWR sky130_fd_sc_hd__fill_2
XFILLER_11_11 VGND VGND VPWR VPWR sky130_fd_sc_hd__decap_3
XFILLER_2_6 VGND VGND VPWR VPWR sky130_fd_sc_hd__fill_1
XFILLER_46_203 VGND VGND VPWR VPWR sky130_fd_sc_hd__decap_3
XFILLER_46_247 VGND VGND VPWR VPWR sky130_fd_sc_hd__decap_3
XFILLER_36_85 VGND VGND VPWR VPWR sky130_fd_sc_hd__decap_3
Xinput38 i_transmit_data[2] VGND VGND VPWR VPWR input38/X sky130_fd_sc_hd__clkdlybuf4s25_1
Xinput27 i_mode_reg[7] VGND VGND VPWR VPWR input27/X sky130_fd_sc_hd__clkdlybuf4s25_1
Xinput16 i_config_reg[0] VGND VGND VPWR VPWR _1184_/D sky130_fd_sc_hd__clkdlybuf4s25_1
X_1221_ _1226_/CLK _1221_/D _1029_/X VGND VGND VPWR VPWR _1221_/Q sky130_fd_sc_hd__dfrtp_2
XFILLER_37_225 VGND VGND VPWR VPWR sky130_fd_sc_hd__fill_1
XFILLER_37_236 VGND VGND VPWR VPWR sky130_fd_sc_hd__fill_1
X_1152_ clkload7/A _1152_/D _1000_/X VGND VGND VPWR VPWR _1152_/Q sky130_fd_sc_hd__dfstp_2
X_1083_ _1119_/CLK _1083_/D load_slew108/X VGND VGND VPWR VPWR _1083_/Q sky130_fd_sc_hd__dfrtp_2
XFILLER_20_103 VGND VGND VPWR VPWR sky130_fd_sc_hd__fill_2
XFILLER_45_291 VGND VGND VPWR VPWR sky130_fd_sc_hd__fill_2
X_0936_ _1120_/Q _0937_/C _1121_/Q VGND VGND VPWR VPWR _0938_/C sky130_fd_sc_hd__a21o_2
X_0867_ _1177_/Q _1177_/D VGND VGND VPWR VPWR _0867_/X sky130_fd_sc_hd__and2b_2
X_0798_ _1239_/Q _0824_/A VGND VGND VPWR VPWR _0799_/C sky130_fd_sc_hd__or2_2
XFILLER_11_103 VGND VGND VPWR VPWR sky130_fd_sc_hd__decap_3
XFILLER_43_228 VGND VGND VPWR VPWR sky130_fd_sc_hd__decap_3
XFILLER_11_147 VGND VGND VPWR VPWR sky130_fd_sc_hd__decap_3
XFILLER_11_169 VGND VGND VPWR VPWR sky130_fd_sc_hd__decap_3
XFILLER_0_3 VGND VGND VPWR VPWR sky130_fd_sc_hd__decap_3
XTAP_TAPCELL_ROW_6_140 VGND VPWR sky130_fd_sc_hd__tapvpwrvgnd_1
XFILLER_19_225 VGND VGND VPWR VPWR sky130_fd_sc_hd__decap_3
XFILLER_19_247 VGND VGND VPWR VPWR sky130_fd_sc_hd__decap_3
XFILLER_19_269 VGND VGND VPWR VPWR sky130_fd_sc_hd__decap_3
XFILLER_47_95 VGND VGND VPWR VPWR sky130_fd_sc_hd__fill_2
XFILLER_8_12 VGND VGND VPWR VPWR sky130_fd_sc_hd__decap_3
XFILLER_10_180 VGND VGND VPWR VPWR sky130_fd_sc_hd__decap_3
XFILLER_6_195 VGND VGND VPWR VPWR sky130_fd_sc_hd__fill_1
X_0721_ _1131_/Q _1201_/Q VGND VGND VPWR VPWR _0721_/X sky130_fd_sc_hd__xor2_2
X_0652_ _0930_/A _1152_/Q hold221/X _0648_/X VGND VGND VPWR VPWR _1152_/D sky130_fd_sc_hd__a22o_2
X_0583_ _1200_/Q _1211_/Q VGND VGND VPWR VPWR _0600_/B sky130_fd_sc_hd__nor2_2
XFILLER_33_3 VGND VGND VPWR VPWR sky130_fd_sc_hd__decap_3
X_1204_ clkload6/A _1204_/D _1012_/X VGND VGND VPWR VPWR _1204_/Q sky130_fd_sc_hd__dfrtp_2
XFILLER_25_228 VGND VGND VPWR VPWR sky130_fd_sc_hd__decap_3
XFILLER_40_209 VGND VGND VPWR VPWR sky130_fd_sc_hd__decap_3
X_1135_ _1211_/CLK _1135_/D _0983_/X VGND VGND VPWR VPWR _1135_/Q sky130_fd_sc_hd__dfrtp_2
X_1066_ _1067_/A1 _1067_/A2 _1067_/B1 VGND VGND VPWR VPWR _1066_/X sky130_fd_sc_hd__o21a_2
X_0919_ _1086_/Q _1124_/Q VGND VGND VPWR VPWR _0928_/A sky130_fd_sc_hd__xnor2_2
XFILLER_17_21 VGND VGND VPWR VPWR sky130_fd_sc_hd__fill_1
XFILLER_17_54 VGND VGND VPWR VPWR sky130_fd_sc_hd__fill_2
XFILLER_24_261 VGND VGND VPWR VPWR sky130_fd_sc_hd__decap_3
XFILLER_15_294 VGND VGND VPWR VPWR sky130_fd_sc_hd__decap_3
XFILLER_30_231 VGND VGND VPWR VPWR sky130_fd_sc_hd__fill_1
XFILLER_30_253 VGND VGND VPWR VPWR sky130_fd_sc_hd__decap_3
X_0704_ _1213_/Q _0704_/B _0704_/C _1214_/Q VGND VGND VPWR VPWR _0708_/B sky130_fd_sc_hd__or4b_2
X_0635_ _1251_/Q _1144_/Q VGND VGND VPWR VPWR _0635_/X sky130_fd_sc_hd__and2b_2
X_0566_ _0566_/A VGND VGND VPWR VPWR _0566_/Y sky130_fd_sc_hd__inv_2
XTAP_TAPCELL_ROW_0_113 VGND VPWR sky130_fd_sc_hd__tapvpwrvgnd_1
X_1118_ _1191_/CLK _1118_/D load_slew102/X VGND VGND VPWR VPWR _1118_/Q sky130_fd_sc_hd__dfrtp_2
X_1049_ _1053_/A1 _1053_/A2 _1049_/B1 VGND VGND VPWR VPWR _1049_/X sky130_fd_sc_hd__o21a_2
XTAP_TAPCELL_ROW_23_226 VGND VPWR sky130_fd_sc_hd__tapvpwrvgnd_1
XFILLER_0_113 VGND VGND VPWR VPWR sky130_fd_sc_hd__fill_2
XFILLER_48_106 VGND VGND VPWR VPWR sky130_fd_sc_hd__decap_3
XFILLER_48_139 VGND VGND VPWR VPWR sky130_fd_sc_hd__fill_1
XFILLER_28_97 VGND VGND VPWR VPWR sky130_fd_sc_hd__fill_2
XFILLER_12_220 VGND VGND VPWR VPWR sky130_fd_sc_hd__decap_3
XFILLER_12_253 VGND VGND VPWR VPWR sky130_fd_sc_hd__decap_3
XFILLER_44_74 VGND VGND VPWR VPWR sky130_fd_sc_hd__decap_3
XFILLER_44_85 VGND VGND VPWR VPWR sky130_fd_sc_hd__decap_3
XFILLER_44_96 VGND VGND VPWR VPWR sky130_fd_sc_hd__decap_3
XFILLER_8_246 VGND VGND VPWR VPWR sky130_fd_sc_hd__decap_3
XFILLER_47_150 VGND VGND VPWR VPWR sky130_fd_sc_hd__decap_3
XFILLER_50_304 VGND VGND VPWR VPWR sky130_fd_sc_hd__decap_3
Xhold202 _1114_/Q VGND VGND VPWR VPWR hold202/X sky130_fd_sc_hd__dlygate4sd3_1
Xhold213 _1275_/Q VGND VGND VPWR VPWR hold213/X sky130_fd_sc_hd__dlygate4sd3_1
Xhold224 _0647_/X VGND VGND VPWR VPWR _1145_/D sky130_fd_sc_hd__dlygate4sd3_1
Xhold235 _1270_/Q VGND VGND VPWR VPWR hold235/X sky130_fd_sc_hd__dlygate4sd3_1
Xhold246 _1264_/Q VGND VGND VPWR VPWR hold246/X sky130_fd_sc_hd__dlygate4sd3_1
Xhold257 _1087_/Q VGND VGND VPWR VPWR hold257/X sky130_fd_sc_hd__dlygate4sd3_1
Xhold279 _1137_/Q VGND VGND VPWR VPWR hold279/X sky130_fd_sc_hd__dlygate4sd3_1
Xhold268 _1088_/Q VGND VGND VPWR VPWR hold268/X sky130_fd_sc_hd__dlygate4sd3_1
X_0618_ _1106_/Q _1081_/Q VGND VGND VPWR VPWR _1180_/D sky130_fd_sc_hd__and2_2
X_0549_ _1229_/Q VGND VGND VPWR VPWR _0549_/Y sky130_fd_sc_hd__inv_2
XFILLER_45_109 VGND VGND VPWR VPWR sky130_fd_sc_hd__decap_3
XFILLER_14_88 VGND VGND VPWR VPWR sky130_fd_sc_hd__fill_2
XTAP_TAPCELL_ROW_51_365 VGND VPWR sky130_fd_sc_hd__tapvpwrvgnd_1
XFILLER_30_54 VGND VGND VPWR VPWR sky130_fd_sc_hd__fill_1
XFILLER_32_304 VGND VGND VPWR VPWR sky130_fd_sc_hd__decap_3
XFILLER_44_197 VGND VGND VPWR VPWR sky130_fd_sc_hd__decap_3
XTAP_TAPCELL_ROW_42_321 VGND VPWR sky130_fd_sc_hd__tapvpwrvgnd_1
XFILLER_27_109 VGND VGND VPWR VPWR sky130_fd_sc_hd__decap_3
XFILLER_35_131 VGND VGND VPWR VPWR sky130_fd_sc_hd__decap_3
XFILLER_35_175 VGND VGND VPWR VPWR sky130_fd_sc_hd__decap_3
XFILLER_50_156 VGND VGND VPWR VPWR sky130_fd_sc_hd__decap_3
XFILLER_50_189 VGND VGND VPWR VPWR sky130_fd_sc_hd__decap_3
XFILLER_14_304 VGND VGND VPWR VPWR sky130_fd_sc_hd__decap_3
XFILLER_26_197 VGND VGND VPWR VPWR sky130_fd_sc_hd__fill_2
XFILLER_41_97 VGND VGND VPWR VPWR sky130_fd_sc_hd__decap_3
XFILLER_49_223 VGND VGND VPWR VPWR sky130_fd_sc_hd__fill_1
XFILLER_49_234 VGND VGND VPWR VPWR sky130_fd_sc_hd__decap_3
XFILLER_49_267 VGND VGND VPWR VPWR sky130_fd_sc_hd__decap_3
XFILLER_32_134 VGND VGND VPWR VPWR sky130_fd_sc_hd__fill_2
X_0952_ _1126_/Q _0955_/C VGND VGND VPWR VPWR _0953_/C sky130_fd_sc_hd__nand2_2
X_0883_ _0891_/A _1270_/Q VGND VGND VPWR VPWR _0884_/S sky130_fd_sc_hd__nand2_2
XFILLER_23_167 VGND VGND VPWR VPWR sky130_fd_sc_hd__fill_1
XFILLER_46_226 VGND VGND VPWR VPWR sky130_fd_sc_hd__decap_3
XFILLER_14_167 VGND VGND VPWR VPWR sky130_fd_sc_hd__decap_3
Xinput39 i_transmit_data[3] VGND VGND VPWR VPWR input39/X sky130_fd_sc_hd__clkdlybuf4s25_1
Xinput28 i_rst_n VGND VGND VPWR VPWR input28/X sky130_fd_sc_hd__clkdlybuf4s25_1
Xinput17 i_config_reg[1] VGND VGND VPWR VPWR _1183_/D sky130_fd_sc_hd__clkdlybuf4s25_1
XFILLER_28_6 VGND VGND VPWR VPWR sky130_fd_sc_hd__fill_1
X_1220_ _1226_/CLK _1220_/D _1028_/X VGND VGND VPWR VPWR _1220_/Q sky130_fd_sc_hd__dfrtp_2
X_1151_ _1236_/CLK _1151_/D _0999_/X VGND VGND VPWR VPWR _1151_/Q sky130_fd_sc_hd__dfrtp_2
XFILLER_37_248 VGND VGND VPWR VPWR sky130_fd_sc_hd__decap_3
X_1082_ _1278_/CLK _1082_/D load_slew99/X VGND VGND VPWR VPWR _1082_/Q sky130_fd_sc_hd__dfrtp_2
X_0935_ _0956_/A _0935_/B _0935_/C VGND VGND VPWR VPWR _1120_/D sky130_fd_sc_hd__and3_2
X_0866_ hold217/X _0865_/X _0862_/Y VGND VGND VPWR VPWR _1091_/D sky130_fd_sc_hd__o21a_2
XTAP_TAPCELL_ROW_15_184 VGND VPWR sky130_fd_sc_hd__tapvpwrvgnd_1
X_0797_ _1239_/Q _0824_/A VGND VGND VPWR VPWR _0799_/B sky130_fd_sc_hd__nand2_2
XFILLER_28_248 VGND VGND VPWR VPWR sky130_fd_sc_hd__decap_3
XFILLER_28_259 VGND VGND VPWR VPWR sky130_fd_sc_hd__fill_2
XFILLER_51_240 VGND VGND VPWR VPWR sky130_fd_sc_hd__decap_3
XFILLER_51_262 VGND VGND VPWR VPWR sky130_fd_sc_hd__decap_3
XFILLER_51_284 VGND VGND VPWR VPWR sky130_fd_sc_hd__decap_3
XFILLER_11_159 VGND VGND VPWR VPWR sky130_fd_sc_hd__fill_1
XFILLER_22_88 VGND VGND VPWR VPWR sky130_fd_sc_hd__decap_3
XFILLER_7_108 VGND VGND VPWR VPWR sky130_fd_sc_hd__decap_3
XFILLER_7_119 VGND VGND VPWR VPWR sky130_fd_sc_hd__decap_3
XTAP_TAPCELL_ROW_6_141 VGND VPWR sky130_fd_sc_hd__tapvpwrvgnd_1
XFILLER_27_281 VGND VGND VPWR VPWR sky130_fd_sc_hd__decap_3
XTAP_TAPCELL_ROW_29_254 VGND VPWR sky130_fd_sc_hd__tapvpwrvgnd_1
XFILLER_42_240 VGND VGND VPWR VPWR sky130_fd_sc_hd__decap_3
X_0720_ _1133_/Q _1203_/Q VGND VGND VPWR VPWR _0720_/X sky130_fd_sc_hd__xor2_2
XFILLER_8_79 VGND VGND VPWR VPWR sky130_fd_sc_hd__decap_3
XFILLER_6_141 VGND VGND VPWR VPWR sky130_fd_sc_hd__decap_3
X_0651_ _1129_/Q _1153_/Q hold172/X _1211_/Q VGND VGND VPWR VPWR _0651_/X sky130_fd_sc_hd__a22o_2
X_0582_ _1138_/Q _1137_/Q _0592_/A _1139_/Q VGND VGND VPWR VPWR _0585_/A sky130_fd_sc_hd__a31o_2
XFILLER_26_3 VGND VGND VPWR VPWR sky130_fd_sc_hd__fill_2
X_1203_ clkload6/A _1203_/D _1011_/X VGND VGND VPWR VPWR _1203_/Q sky130_fd_sc_hd__dfrtp_2
X_1134_ _1211_/CLK _1134_/D _0982_/X VGND VGND VPWR VPWR _1134_/Q sky130_fd_sc_hd__dfrtp_2
XFILLER_33_262 VGND VGND VPWR VPWR sky130_fd_sc_hd__decap_3
X_1065_ _1067_/A1 _1067_/A2 _1067_/B1 VGND VGND VPWR VPWR _1065_/X sky130_fd_sc_hd__o21a_2
X_0918_ hold182/X _0678_/X _0904_/X _0917_/X VGND VGND VPWR VPWR _1118_/D sky130_fd_sc_hd__o22a_2
X_0849_ _1178_/Q _0849_/B _0849_/C VGND VGND VPWR VPWR _0849_/Y sky130_fd_sc_hd__nor3_2
XFILLER_0_306 VGND VGND VPWR VPWR sky130_fd_sc_hd__fill_2
XFILLER_17_88 VGND VGND VPWR VPWR sky130_fd_sc_hd__decap_3
XFILLER_24_251 VGND VGND VPWR VPWR sky130_fd_sc_hd__fill_1
XFILLER_24_273 VGND VGND VPWR VPWR sky130_fd_sc_hd__decap_3
XFILLER_33_54 VGND VGND VPWR VPWR sky130_fd_sc_hd__fill_2
XFILLER_15_251 VGND VGND VPWR VPWR sky130_fd_sc_hd__fill_2
XFILLER_30_276 VGND VGND VPWR VPWR sky130_fd_sc_hd__decap_3
X_0703_ _1069_/Q _1219_/Q VGND VGND VPWR VPWR _0704_/C sky130_fd_sc_hd__and2b_2
X_0634_ _0634_/A _0634_/B VGND VGND VPWR VPWR _1209_/D sky130_fd_sc_hd__xnor2_2
X_0565_ _1240_/Q VGND VGND VPWR VPWR _0565_/Y sky130_fd_sc_hd__inv_2
X_1117_ _1278_/CLK _1117_/D load_slew96/X VGND VGND VPWR VPWR _1117_/Q sky130_fd_sc_hd__dfrtp_2
X_1048_ _1053_/A1 _1053_/A2 _1049_/B1 VGND VGND VPWR VPWR _1048_/X sky130_fd_sc_hd__o21a_2
XTAP_TAPCELL_ROW_23_227 VGND VPWR sky130_fd_sc_hd__tapvpwrvgnd_1
XPHY_EDGE_ROW_3_Right_3 VGND VGND VPWR VPWR sky130_fd_sc_hd__decap_3
XFILLER_44_302 VGND VGND VPWR VPWR sky130_fd_sc_hd__decap_3
XFILLER_12_265 VGND VGND VPWR VPWR sky130_fd_sc_hd__decap_3
XFILLER_8_269 VGND VGND VPWR VPWR sky130_fd_sc_hd__decap_3
XFILLER_10_6 VGND VGND VPWR VPWR sky130_fd_sc_hd__decap_3
XFILLER_47_162 VGND VGND VPWR VPWR sky130_fd_sc_hd__decap_3
XFILLER_47_184 VGND VGND VPWR VPWR sky130_fd_sc_hd__decap_3
XPHY_EDGE_ROW_17_Left_69 VGND VGND VPWR VPWR sky130_fd_sc_hd__decap_3
Xhold203 _1112_/Q VGND VGND VPWR VPWR hold203/X sky130_fd_sc_hd__dlygate4sd3_1
Xhold214 _1231_/Q VGND VGND VPWR VPWR hold214/X sky130_fd_sc_hd__dlygate4sd3_1
Xhold225 _1287_/A VGND VGND VPWR VPWR hold225/X sky130_fd_sc_hd__dlygate4sd3_1
Xhold236 _0966_/X VGND VGND VPWR VPWR _1270_/D sky130_fd_sc_hd__dlygate4sd3_1
Xhold247 _1276_/Q VGND VGND VPWR VPWR hold247/X sky130_fd_sc_hd__dlygate4sd3_1
Xhold258 _1250_/Q VGND VGND VPWR VPWR hold258/X sky130_fd_sc_hd__dlygate4sd3_1
Xhold269 _1089_/Q VGND VGND VPWR VPWR hold269/X sky130_fd_sc_hd__dlygate4sd3_1
X_0617_ _1106_/Q _0617_/B VGND VGND VPWR VPWR _1177_/D sky130_fd_sc_hd__and2_2
X_0548_ _1152_/Q VGND VGND VPWR VPWR _0548_/Y sky130_fd_sc_hd__inv_2
XFILLER_38_184 VGND VGND VPWR VPWR sky130_fd_sc_hd__fill_1
XFILLER_38_195 VGND VGND VPWR VPWR sky130_fd_sc_hd__fill_1
XFILLER_41_305 VGND VGND VPWR VPWR sky130_fd_sc_hd__decap_3
XTAP_TAPCELL_ROW_51_366 VGND VPWR sky130_fd_sc_hd__tapvpwrvgnd_1
XFILLER_39_20 VGND VGND VPWR VPWR sky130_fd_sc_hd__fill_1
XTAP_TAPCELL_ROW_42_322 VGND VPWR sky130_fd_sc_hd__tapvpwrvgnd_1
XFILLER_4_261 VGND VGND VPWR VPWR sky130_fd_sc_hd__fill_1
XFILLER_35_110 VGND VGND VPWR VPWR sky130_fd_sc_hd__fill_2
XFILLER_50_168 VGND VGND VPWR VPWR sky130_fd_sc_hd__decap_3
XFILLER_41_113 VGND VGND VPWR VPWR sky130_fd_sc_hd__fill_2
XFILLER_41_157 VGND VGND VPWR VPWR sky130_fd_sc_hd__decap_3
XFILLER_1_297 VGND VGND VPWR VPWR sky130_fd_sc_hd__decap_3
XFILLER_49_202 VGND VGND VPWR VPWR sky130_fd_sc_hd__decap_3
XFILLER_49_246 VGND VGND VPWR VPWR sky130_fd_sc_hd__decap_3
XFILLER_49_279 VGND VGND VPWR VPWR sky130_fd_sc_hd__fill_1
X_0951_ _1126_/Q _0955_/C VGND VGND VPWR VPWR _0953_/B sky130_fd_sc_hd__or2_2
X_0882_ _0575_/A hold166/X _0882_/S VGND VGND VPWR VPWR _1100_/D sky130_fd_sc_hd__mux2_1
XFILLER_23_124 VGND VGND VPWR VPWR sky130_fd_sc_hd__decap_3
XFILLER_39_290 VGND VGND VPWR VPWR sky130_fd_sc_hd__decap_3
XFILLER_46_238 VGND VGND VPWR VPWR sky130_fd_sc_hd__decap_3
Xinput18 i_config_reg[2] VGND VGND VPWR VPWR input18/X sky130_fd_sc_hd__clkdlybuf4s25_1
Xinput29 i_slave_addr_reg[0] VGND VGND VPWR VPWR _0692_/A sky130_fd_sc_hd__clkdlybuf4s25_1
X_1150_ clkload8/A _1150_/D _0998_/X VGND VGND VPWR VPWR _1150_/Q sky130_fd_sc_hd__dfrtp_2
XFILLER_45_271 VGND VGND VPWR VPWR sky130_fd_sc_hd__decap_3
X_1081_ _1191_/CLK _1081_/D fanout101/X VGND VGND VPWR VPWR _1081_/Q sky130_fd_sc_hd__dfrtp_2
X_0934_ _1120_/Q _0937_/C VGND VGND VPWR VPWR _0935_/C sky130_fd_sc_hd__nand2_2
X_0865_ _1180_/Q _1180_/D VGND VGND VPWR VPWR _0865_/X sky130_fd_sc_hd__and2b_2
XTAP_TAPCELL_ROW_15_185 VGND VPWR sky130_fd_sc_hd__tapvpwrvgnd_1
X_0796_ _0824_/A _0796_/B _0804_/A VGND VGND VPWR VPWR _1238_/D sky130_fd_sc_hd__and3b_2
XFILLER_11_116 VGND VGND VPWR VPWR sky130_fd_sc_hd__fill_2
XFILLER_51_274 VGND VGND VPWR VPWR sky130_fd_sc_hd__decap_3
XFILLER_51_296 VGND VGND VPWR VPWR sky130_fd_sc_hd__decap_3
XTAP_TAPCELL_ROW_38_299 VGND VPWR sky130_fd_sc_hd__tapvpwrvgnd_1
XFILLER_22_56 VGND VGND VPWR VPWR sky130_fd_sc_hd__fill_2
XPHY_EDGE_ROW_5_Left_57 VGND VGND VPWR VPWR sky130_fd_sc_hd__decap_3
XFILLER_47_42 VGND VGND VPWR VPWR sky130_fd_sc_hd__decap_3
XTAP_TAPCELL_ROW_6_142 VGND VPWR sky130_fd_sc_hd__tapvpwrvgnd_1
XFILLER_27_260 VGND VGND VPWR VPWR sky130_fd_sc_hd__decap_3
XTAP_TAPCELL_ROW_29_255 VGND VPWR sky130_fd_sc_hd__tapvpwrvgnd_1
XFILLER_10_193 VGND VGND VPWR VPWR sky130_fd_sc_hd__decap_3
XFILLER_6_153 VGND VGND VPWR VPWR sky130_fd_sc_hd__decap_3
X_0650_ _1128_/Q _1152_/Q hold172/X _0547_/Y VGND VGND VPWR VPWR _1154_/D sky130_fd_sc_hd__a22o_2
X_0581_ _1136_/Q _1135_/Q _1134_/Q _0598_/A VGND VGND VPWR VPWR _0592_/A sky130_fd_sc_hd__and4_2
X_1202_ clkload6/A _1202_/D _1010_/X VGND VGND VPWR VPWR _1202_/Q sky130_fd_sc_hd__dfrtp_2
X_1133_ _1211_/CLK _1133_/D _0981_/X VGND VGND VPWR VPWR _1133_/Q sky130_fd_sc_hd__dfrtp_2
X_1064_ _1064_/A1 _1064_/A2 _1064_/B1 VGND VGND VPWR VPWR _1064_/X sky130_fd_sc_hd__o21a_2
X_0917_ _1076_/Q input43/X _0917_/S VGND VGND VPWR VPWR _0917_/X sky130_fd_sc_hd__mux2_1
X_0848_ _1183_/Q _1183_/D _1036_/B1 VGND VGND VPWR VPWR _0849_/C sky130_fd_sc_hd__or3b_2
X_0779_ _1226_/Q _1225_/Q VGND VGND VPWR VPWR _0780_/D sky130_fd_sc_hd__and2_2
XPHY_EDGE_ROW_47_Left_99 VGND VGND VPWR VPWR sky130_fd_sc_hd__decap_3
XTAP_TAPCELL_ROW_34_280 VGND VPWR sky130_fd_sc_hd__tapvpwrvgnd_1
XFILLER_15_274 VGND VGND VPWR VPWR sky130_fd_sc_hd__decap_3
XFILLER_30_200 VGND VGND VPWR VPWR sky130_fd_sc_hd__fill_2
XFILLER_30_222 VGND VGND VPWR VPWR sky130_fd_sc_hd__decap_3
X_0702_ _1215_/Q _1218_/Q _1220_/Q _1216_/Q VGND VGND VPWR VPWR _0704_/B sky130_fd_sc_hd__or4b_2
X_0633_ _0634_/B _0633_/B VGND VGND VPWR VPWR _1208_/D sky130_fd_sc_hd__nand2_2
X_0564_ _1239_/Q VGND VGND VPWR VPWR _0564_/Y sky130_fd_sc_hd__inv_2
XFILLER_0_81 VGND VGND VPWR VPWR sky130_fd_sc_hd__decap_3
X_1116_ _1278_/CLK _1116_/D load_slew96/X VGND VGND VPWR VPWR _1116_/Q sky130_fd_sc_hd__dfrtp_2
X_1047_ _1053_/A1 _1053_/A2 _1049_/B1 VGND VGND VPWR VPWR _1047_/X sky130_fd_sc_hd__o21a_2
XTAP_TAPCELL_ROW_48_350 VGND VPWR sky130_fd_sc_hd__tapvpwrvgnd_1
XTAP_TAPCELL_ROW_0_104 VGND VPWR sky130_fd_sc_hd__tapvpwrvgnd_1
XFILLER_21_211 VGND VGND VPWR VPWR sky130_fd_sc_hd__decap_3
XTAP_TAPCELL_ROW_23_228 VGND VPWR sky130_fd_sc_hd__tapvpwrvgnd_1
XFILLER_28_55 VGND VGND VPWR VPWR sky130_fd_sc_hd__decap_3
XFILLER_8_226 VGND VGND VPWR VPWR sky130_fd_sc_hd__fill_2
XPHY_EDGE_ROW_8_Left_60 VGND VGND VPWR VPWR sky130_fd_sc_hd__decap_3
XFILLER_35_303 VGND VGND VPWR VPWR sky130_fd_sc_hd__decap_3
XFILLER_47_141 VGND VGND VPWR VPWR sky130_fd_sc_hd__decap_3
XFILLER_47_196 VGND VGND VPWR VPWR sky130_fd_sc_hd__decap_3
XPHY_EDGE_ROW_13_Right_13 VGND VGND VPWR VPWR sky130_fd_sc_hd__decap_3
XTAP_TAPCELL_ROW_20_209 VGND VPWR sky130_fd_sc_hd__tapvpwrvgnd_1
XPHY_EDGE_ROW_22_Right_22 VGND VGND VPWR VPWR sky130_fd_sc_hd__decap_3
Xhold204 _1283_/A VGND VGND VPWR VPWR _0609_/B sky130_fd_sc_hd__dlygate4sd3_1
Xhold215 _0665_/X VGND VGND VPWR VPWR _1167_/D sky130_fd_sc_hd__dlygate4sd3_1
Xhold226 _1277_/Q VGND VGND VPWR VPWR hold226/X sky130_fd_sc_hd__dlygate4sd3_1
Xhold237 _1150_/Q VGND VGND VPWR VPWR hold237/X sky130_fd_sc_hd__dlygate4sd3_1
Xhold248 _1213_/Q VGND VGND VPWR VPWR hold248/X sky130_fd_sc_hd__dlygate4sd3_1
Xhold259 _1083_/Q VGND VGND VPWR VPWR hold259/X sky130_fd_sc_hd__dlygate4sd3_1
X_0616_ _0970_/S _0616_/B VGND VGND VPWR VPWR _1198_/D sky130_fd_sc_hd__and2_2
XFILLER_38_130 VGND VGND VPWR VPWR sky130_fd_sc_hd__fill_2
X_0547_ _1211_/Q VGND VGND VPWR VPWR _0547_/Y sky130_fd_sc_hd__inv_2
XPHY_EDGE_ROW_31_Right_31 VGND VGND VPWR VPWR sky130_fd_sc_hd__decap_3
XFILLER_14_46 VGND VGND VPWR VPWR sky130_fd_sc_hd__decap_3
XTAP_TAPCELL_ROW_51_367 VGND VPWR sky130_fd_sc_hd__tapvpwrvgnd_1
XPHY_EDGE_ROW_40_Right_40 VGND VGND VPWR VPWR sky130_fd_sc_hd__decap_3
XFILLER_39_54 VGND VGND VPWR VPWR sky130_fd_sc_hd__fill_2
XFILLER_17_303 VGND VGND VPWR VPWR sky130_fd_sc_hd__decap_3
XPHY_EDGE_ROW_34_Left_86 VGND VGND VPWR VPWR sky130_fd_sc_hd__decap_3
XTAP_TAPCELL_ROW_42_323 VGND VPWR sky130_fd_sc_hd__tapvpwrvgnd_1
XFILLER_4_240 VGND VGND VPWR VPWR sky130_fd_sc_hd__fill_1
XFILLER_23_306 VGND VGND VPWR VPWR sky130_fd_sc_hd__fill_2
XFILLER_35_166 VGND VGND VPWR VPWR sky130_fd_sc_hd__fill_2
XFILLER_50_103 VGND VGND VPWR VPWR sky130_fd_sc_hd__decap_3
XFILLER_50_136 VGND VGND VPWR VPWR sky130_fd_sc_hd__decap_3
XFILLER_50_147 VGND VGND VPWR VPWR sky130_fd_sc_hd__decap_3
XFILLER_25_34 VGND VGND VPWR VPWR sky130_fd_sc_hd__fill_1
XFILLER_41_103 VGND VGND VPWR VPWR sky130_fd_sc_hd__decap_3
XFILLER_1_276 VGND VGND VPWR VPWR sky130_fd_sc_hd__decap_3
XFILLER_2_38 VGND VGND VPWR VPWR sky130_fd_sc_hd__decap_3
XFILLER_49_214 VGND VGND VPWR VPWR sky130_fd_sc_hd__decap_3
XFILLER_49_225 VGND VGND VPWR VPWR sky130_fd_sc_hd__decap_3
XFILLER_49_258 VGND VGND VPWR VPWR sky130_fd_sc_hd__decap_3
XFILLER_17_199 VGND VGND VPWR VPWR sky130_fd_sc_hd__decap_3
X_0950_ _0955_/C _0956_/A _0950_/C VGND VGND VPWR VPWR _1125_/D sky130_fd_sc_hd__and3b_2
X_0881_ _0891_/A _1264_/Q VGND VGND VPWR VPWR _0882_/S sky130_fd_sc_hd__nand2_2
XFILLER_48_280 VGND VGND VPWR VPWR sky130_fd_sc_hd__decap_3
XFILLER_23_103 VGND VGND VPWR VPWR sky130_fd_sc_hd__decap_3
XFILLER_46_206 VGND VGND VPWR VPWR sky130_fd_sc_hd__decap_3
XFILLER_14_158 VGND VGND VPWR VPWR sky130_fd_sc_hd__decap_3
Xinput19 i_config_reg[3] VGND VGND VPWR VPWR input19/X sky130_fd_sc_hd__clkdlybuf4s25_1
XFILLER_37_217 VGND VGND VPWR VPWR sky130_fd_sc_hd__decap_3
X_1080_ _1191_/CLK _1080_/D load_slew102/X VGND VGND VPWR VPWR _1080_/Q sky130_fd_sc_hd__dfrtp_2
XFILLER_45_261 VGND VGND VPWR VPWR sky130_fd_sc_hd__fill_2
XTAP_TAPCELL_ROW_15_186 VGND VPWR sky130_fd_sc_hd__tapvpwrvgnd_1
X_0933_ _1120_/Q _0937_/C VGND VGND VPWR VPWR _0935_/B sky130_fd_sc_hd__or2_2
X_0864_ _0609_/B _0863_/X _0862_/Y VGND VGND VPWR VPWR _1090_/D sky130_fd_sc_hd__o21a_2
X_0795_ _1236_/Q _1235_/Q _1237_/Q _1238_/Q VGND VGND VPWR VPWR _0796_/B sky130_fd_sc_hd__a31o_2
XPHY_EDGE_ROW_21_Left_73 VGND VGND VPWR VPWR sky130_fd_sc_hd__decap_3
XFILLER_28_239 VGND VGND VPWR VPWR sky130_fd_sc_hd__decap_3
XFILLER_51_231 VGND VGND VPWR VPWR sky130_fd_sc_hd__decap_3
X_1278_ _1278_/CLK _1278_/D fanout97/X VGND VGND VPWR VPWR _1278_/Q sky130_fd_sc_hd__dfrtp_2
XFILLER_11_106 VGND VGND VPWR VPWR sky130_fd_sc_hd__decap_3
XFILLER_51_253 VGND VGND VPWR VPWR sky130_fd_sc_hd__decap_3
XFILLER_0_6 VGND VGND VPWR VPWR sky130_fd_sc_hd__decap_3
XFILLER_22_68 VGND VGND VPWR VPWR sky130_fd_sc_hd__decap_3
XFILLER_19_228 VGND VGND VPWR VPWR sky130_fd_sc_hd__decap_3
XTAP_TAPCELL_ROW_6_143 VGND VPWR sky130_fd_sc_hd__tapvpwrvgnd_1
XFILLER_42_253 VGND VGND VPWR VPWR sky130_fd_sc_hd__fill_1
XTAP_TAPCELL_ROW_29_256 VGND VPWR sky130_fd_sc_hd__tapvpwrvgnd_1
XFILLER_8_15 VGND VGND VPWR VPWR sky130_fd_sc_hd__decap_3
XFILLER_10_183 VGND VGND VPWR VPWR sky130_fd_sc_hd__fill_2
X_1201_ clkload6/A _1201_/D _1009_/X VGND VGND VPWR VPWR _1201_/Q sky130_fd_sc_hd__dfrtp_2
X_0580_ _1135_/Q _1134_/Q _0598_/A VGND VGND VPWR VPWR _0580_/X sky130_fd_sc_hd__and3_2
X_1132_ _1211_/CLK _1132_/D _0980_/X VGND VGND VPWR VPWR _1132_/Q sky130_fd_sc_hd__dfrtp_2
X_1063_ _1063_/A1 _1063_/A2 _1064_/B1 VGND VGND VPWR VPWR _1063_/X sky130_fd_sc_hd__o21a_2
XFILLER_33_253 VGND VGND VPWR VPWR sky130_fd_sc_hd__decap_3
XFILLER_33_275 VGND VGND VPWR VPWR sky130_fd_sc_hd__fill_2
X_0916_ hold183/X _0678_/X _0904_/X _0915_/X VGND VGND VPWR VPWR _1117_/D sky130_fd_sc_hd__o22a_2
X_0847_ hold255/X _0689_/A _0860_/S VGND VGND VPWR VPWR _1076_/D sky130_fd_sc_hd__mux2_1
X_0778_ _0778_/A _0778_/B _0778_/C VGND VGND VPWR VPWR _1225_/D sky130_fd_sc_hd__and3_2
XTAP_TAPCELL_ROW_3_124 VGND VPWR sky130_fd_sc_hd__tapvpwrvgnd_1
XFILLER_17_35 VGND VGND VPWR VPWR sky130_fd_sc_hd__decap_3
XFILLER_17_57 VGND VGND VPWR VPWR sky130_fd_sc_hd__decap_3
XFILLER_24_231 VGND VGND VPWR VPWR sky130_fd_sc_hd__decap_3
XFILLER_24_264 VGND VGND VPWR VPWR sky130_fd_sc_hd__decap_3
XTAP_TAPCELL_ROW_34_281 VGND VPWR sky130_fd_sc_hd__tapvpwrvgnd_1
XFILLER_15_297 VGND VGND VPWR VPWR sky130_fd_sc_hd__decap_3
XFILLER_30_256 VGND VGND VPWR VPWR sky130_fd_sc_hd__decap_3
X_0701_ _1069_/Q _0560_/Y _0700_/X VGND VGND VPWR VPWR _0708_/A sky130_fd_sc_hd__a21o_2
X_0632_ _0632_/A _0632_/B VGND VGND VPWR VPWR _0633_/B sky130_fd_sc_hd__nand2_2
X_0563_ _1237_/Q VGND VGND VPWR VPWR _0563_/Y sky130_fd_sc_hd__inv_2
XFILLER_31_3 VGND VGND VPWR VPWR sky130_fd_sc_hd__decap_3
XFILLER_38_301 VGND VGND VPWR VPWR sky130_fd_sc_hd__decap_3
XFILLER_0_60 VGND VGND VPWR VPWR sky130_fd_sc_hd__decap_3
X_1115_ _1278_/CLK _1115_/D load_slew96/X VGND VGND VPWR VPWR _1115_/Q sky130_fd_sc_hd__dfrtp_2
X_1046_ _1053_/A1 _1053_/A2 _1049_/B1 VGND VGND VPWR VPWR _1046_/X sky130_fd_sc_hd__o21a_2
XTAP_TAPCELL_ROW_48_351 VGND VPWR sky130_fd_sc_hd__tapvpwrvgnd_1
XTAP_TAPCELL_ROW_0_105 VGND VPWR sky130_fd_sc_hd__tapvpwrvgnd_1
XFILLER_12_223 VGND VGND VPWR VPWR sky130_fd_sc_hd__decap_3
XFILLER_12_256 VGND VGND VPWR VPWR sky130_fd_sc_hd__decap_3
XFILLER_44_77 VGND VGND VPWR VPWR sky130_fd_sc_hd__decap_3
XFILLER_44_88 VGND VGND VPWR VPWR sky130_fd_sc_hd__fill_1
XFILLER_44_99 VGND VGND VPWR VPWR sky130_fd_sc_hd__fill_2
XFILLER_5_27 VGND VGND VPWR VPWR sky130_fd_sc_hd__decap_3
XFILLER_8_249 VGND VGND VPWR VPWR sky130_fd_sc_hd__decap_3
XFILLER_47_153 VGND VGND VPWR VPWR sky130_fd_sc_hd__decap_3
XFILLER_47_175 VGND VGND VPWR VPWR sky130_fd_sc_hd__decap_3
XFILLER_50_307 VGND VGND VPWR VPWR sky130_fd_sc_hd__fill_1
Xhold205 _0609_/X VGND VGND VPWR VPWR _1077_/D sky130_fd_sc_hd__dlygate4sd3_1
Xhold216 _1285_/A VGND VGND VPWR VPWR hold216/X sky130_fd_sc_hd__dlygate4sd3_1
Xhold227 _1286_/A VGND VGND VPWR VPWR hold227/X sky130_fd_sc_hd__dlygate4sd3_1
Xhold238 _1179_/Q VGND VGND VPWR VPWR hold238/X sky130_fd_sc_hd__dlygate4sd3_1
Xhold249 _1273_/Q VGND VGND VPWR VPWR hold249/X sky130_fd_sc_hd__dlygate4sd3_1
X_0615_ _0615_/A _0974_/S VGND VGND VPWR VPWR _1197_/D sky130_fd_sc_hd__and2_2
X_0546_ _1234_/Q VGND VGND VPWR VPWR _0546_/Y sky130_fd_sc_hd__inv_2
XFILLER_7_271 VGND VGND VPWR VPWR sky130_fd_sc_hd__fill_2
XFILLER_38_175 VGND VGND VPWR VPWR sky130_fd_sc_hd__decap_3
XFILLER_38_197 VGND VGND VPWR VPWR sky130_fd_sc_hd__decap_3
X_1029_ _1036_/A1 _1036_/A2 _1034_/B1 VGND VGND VPWR VPWR _1029_/X sky130_fd_sc_hd__o21a_2
XTAP_TAPCELL_ROW_51_368 VGND VPWR sky130_fd_sc_hd__tapvpwrvgnd_1
XFILLER_29_164 VGND VGND VPWR VPWR sky130_fd_sc_hd__decap_3
XFILLER_32_307 VGND VGND VPWR VPWR sky130_fd_sc_hd__fill_1
XFILLER_35_134 VGND VGND VPWR VPWR sky130_fd_sc_hd__decap_3
XFILLER_35_178 VGND VGND VPWR VPWR sky130_fd_sc_hd__fill_1
XFILLER_50_159 VGND VGND VPWR VPWR sky130_fd_sc_hd__decap_3
XFILLER_14_307 VGND VGND VPWR VPWR sky130_fd_sc_hd__fill_1
XFILLER_25_57 VGND VGND VPWR VPWR sky130_fd_sc_hd__decap_3
XFILLER_41_137 VGND VGND VPWR VPWR sky130_fd_sc_hd__decap_3
XFILLER_9_3 VGND VGND VPWR VPWR sky130_fd_sc_hd__decap_3
XFILLER_49_237 VGND VGND VPWR VPWR sky130_fd_sc_hd__decap_3
X_0880_ _0575_/A hold165/X _0880_/S VGND VGND VPWR VPWR _1099_/D sky130_fd_sc_hd__mux2_1
XFILLER_48_292 VGND VGND VPWR VPWR sky130_fd_sc_hd__decap_3
XFILLER_31_181 VGND VGND VPWR VPWR sky130_fd_sc_hd__decap_3
XFILLER_46_229 VGND VGND VPWR VPWR sky130_fd_sc_hd__decap_3
XFILLER_36_67 VGND VGND VPWR VPWR sky130_fd_sc_hd__decap_3
XFILLER_39_281 VGND VGND VPWR VPWR sky130_fd_sc_hd__decap_3
XFILLER_22_192 VGND VGND VPWR VPWR sky130_fd_sc_hd__decap_3
X_0932_ _1193_/Q _1186_/Q VGND VGND VPWR VPWR _0937_/C sky130_fd_sc_hd__or2_2
XTAP_TAPCELL_ROW_15_187 VGND VPWR sky130_fd_sc_hd__tapvpwrvgnd_1
X_0863_ _1181_/Q _1187_/Q VGND VGND VPWR VPWR _0863_/X sky130_fd_sc_hd__and2b_2
X_0794_ _1236_/Q _1235_/Q _1237_/Q _1238_/Q VGND VGND VPWR VPWR _0824_/A sky130_fd_sc_hd__and4_2
XFILLER_36_240 VGND VGND VPWR VPWR sky130_fd_sc_hd__decap_3
XFILLER_51_221 VGND VGND VPWR VPWR sky130_fd_sc_hd__decap_3
XFILLER_51_243 VGND VGND VPWR VPWR sky130_fd_sc_hd__decap_3
X_1277_ clkload3/A _1277_/D load_slew102/X VGND VGND VPWR VPWR _1277_/Q sky130_fd_sc_hd__dfrtp_2
XFILLER_51_265 VGND VGND VPWR VPWR sky130_fd_sc_hd__decap_3
XFILLER_51_287 VGND VGND VPWR VPWR sky130_fd_sc_hd__decap_3
Xfanout120 _1034_/B1 VGND VGND VPWR VPWR fanout120/X sky130_fd_sc_hd__clkdlybuf4s25_1
XFILLER_27_240 VGND VGND VPWR VPWR sky130_fd_sc_hd__fill_2
XTAP_TAPCELL_ROW_29_257 VGND VPWR sky130_fd_sc_hd__tapvpwrvgnd_1
XFILLER_42_243 VGND VGND VPWR VPWR sky130_fd_sc_hd__fill_1
XFILLER_6_144 VGND VGND VPWR VPWR sky130_fd_sc_hd__decap_3
XFILLER_6_166 VGND VGND VPWR VPWR sky130_fd_sc_hd__fill_2
X_1200_ clkload7/A _1200_/D _1008_/X VGND VGND VPWR VPWR _1200_/Q sky130_fd_sc_hd__dfrtp_2
XFILLER_18_262 VGND VGND VPWR VPWR sky130_fd_sc_hd__decap_3
XFILLER_33_221 VGND VGND VPWR VPWR sky130_fd_sc_hd__decap_3
X_1131_ clkload6/A _1131_/D _0979_/X VGND VGND VPWR VPWR _1131_/Q sky130_fd_sc_hd__dfrtp_2
X_1062_ _1063_/A1 _1063_/A2 _1064_/B1 VGND VGND VPWR VPWR _1062_/X sky130_fd_sc_hd__o21a_2
X_0915_ _1075_/Q input42/X _0917_/S VGND VGND VPWR VPWR _0915_/X sky130_fd_sc_hd__mux2_1
X_0846_ hold254/X _0695_/A _0860_/S VGND VGND VPWR VPWR _1075_/D sky130_fd_sc_hd__mux2_1
X_0777_ _1225_/Q _0777_/B VGND VGND VPWR VPWR _0778_/C sky130_fd_sc_hd__nand2_2
XTAP_TAPCELL_ROW_3_125 VGND VPWR sky130_fd_sc_hd__tapvpwrvgnd_1
XFILLER_24_276 VGND VGND VPWR VPWR sky130_fd_sc_hd__decap_3
XFILLER_33_24 VGND VGND VPWR VPWR sky130_fd_sc_hd__fill_2
XFILLER_33_57 VGND VGND VPWR VPWR sky130_fd_sc_hd__decap_3
XTAP_TAPCELL_ROW_34_282 VGND VPWR sky130_fd_sc_hd__tapvpwrvgnd_1
XPHY_EDGE_ROW_49_Left_101 VGND VGND VPWR VPWR sky130_fd_sc_hd__decap_3
XFILLER_47_302 VGND VGND VPWR VPWR sky130_fd_sc_hd__decap_3
X_0700_ _1068_/Q _1217_/Q VGND VGND VPWR VPWR _0700_/X sky130_fd_sc_hd__xor2_2
X_0631_ _0632_/A _0632_/B VGND VGND VPWR VPWR _0634_/B sky130_fd_sc_hd__or2_2
X_0562_ _0562_/A VGND VGND VPWR VPWR _0562_/Y sky130_fd_sc_hd__inv_2
X_1114_ clkload5/A _1114_/D fanout97/X VGND VGND VPWR VPWR _1114_/Q sky130_fd_sc_hd__dfrtp_2
XTAP_TAPCELL_ROW_48_352 VGND VPWR sky130_fd_sc_hd__tapvpwrvgnd_1
XTAP_TAPCELL_ROW_0_106 VGND VPWR sky130_fd_sc_hd__tapvpwrvgnd_1
X_1045_ _1053_/A1 _1053_/A2 _1049_/B1 VGND VGND VPWR VPWR _1045_/X sky130_fd_sc_hd__o21a_2
X_0829_ _1250_/Q _1249_/Q _0824_/X _0815_/A VGND VGND VPWR VPWR _0830_/B sky130_fd_sc_hd__a31o_2
XFILLER_44_305 VGND VGND VPWR VPWR sky130_fd_sc_hd__decap_3
XFILLER_44_34 VGND VGND VPWR VPWR sky130_fd_sc_hd__decap_3
XFILLER_12_268 VGND VGND VPWR VPWR sky130_fd_sc_hd__decap_3
XFILLER_5_39 VGND VGND VPWR VPWR sky130_fd_sc_hd__fill_1
XFILLER_10_9 VGND VGND VPWR VPWR sky130_fd_sc_hd__decap_3
XFILLER_47_132 VGND VGND VPWR VPWR sky130_fd_sc_hd__fill_2
XFILLER_47_165 VGND VGND VPWR VPWR sky130_fd_sc_hd__decap_3
XFILLER_47_187 VGND VGND VPWR VPWR sky130_fd_sc_hd__decap_3
Xhold206 _1246_/Q VGND VGND VPWR VPWR hold206/X sky130_fd_sc_hd__dlygate4sd3_1
Xhold217 _1284_/A VGND VGND VPWR VPWR hold217/X sky130_fd_sc_hd__dlygate4sd3_1
Xhold228 _1268_/Q VGND VGND VPWR VPWR hold228/X sky130_fd_sc_hd__dlygate4sd3_1
Xhold239 _1265_/Q VGND VGND VPWR VPWR hold239/X sky130_fd_sc_hd__dlygate4sd3_1
X_0614_ _0614_/A _1212_/D VGND VGND VPWR VPWR _1146_/D sky130_fd_sc_hd__and2_2
X_0545_ _1197_/Q VGND VGND VPWR VPWR _0545_/Y sky130_fd_sc_hd__inv_2
XPHY_EDGE_ROW_7_Right_7 VGND VGND VPWR VPWR sky130_fd_sc_hd__decap_3
XFILLER_14_26 VGND VGND VPWR VPWR sky130_fd_sc_hd__fill_2
X_1028_ _1036_/A1 _1036_/A2 _1034_/B1 VGND VGND VPWR VPWR _1028_/X sky130_fd_sc_hd__o21a_2
XTAP_TAPCELL_ROW_51_369 VGND VPWR sky130_fd_sc_hd__tapvpwrvgnd_1
XFILLER_35_113 VGND VGND VPWR VPWR sky130_fd_sc_hd__fill_1
XFILLER_26_168 VGND VGND VPWR VPWR sky130_fd_sc_hd__decap_3
XFILLER_49_205 VGND VGND VPWR VPWR sky130_fd_sc_hd__decap_3
XFILLER_17_113 VGND VGND VPWR VPWR sky130_fd_sc_hd__fill_2
XFILLER_49_249 VGND VGND VPWR VPWR sky130_fd_sc_hd__decap_3
XFILLER_23_127 VGND VGND VPWR VPWR sky130_fd_sc_hd__decap_3
XFILLER_48_271 VGND VGND VPWR VPWR sky130_fd_sc_hd__decap_3
XFILLER_31_160 VGND VGND VPWR VPWR sky130_fd_sc_hd__fill_1
XFILLER_39_271 VGND VGND VPWR VPWR sky130_fd_sc_hd__decap_3
XFILLER_39_293 VGND VGND VPWR VPWR sky130_fd_sc_hd__decap_3
XFILLER_36_79 VGND VGND VPWR VPWR sky130_fd_sc_hd__decap_3
XFILLER_45_252 VGND VGND VPWR VPWR sky130_fd_sc_hd__decap_3
XFILLER_45_274 VGND VGND VPWR VPWR sky130_fd_sc_hd__decap_3
X_0931_ _0927_/X _0928_/X _0930_/A VGND VGND VPWR VPWR _0956_/A sky130_fd_sc_hd__a21oi_2
X_0862_ _1182_/Q _1178_/Q VGND VGND VPWR VPWR _0862_/Y sky130_fd_sc_hd__nand2b_2
XTAP_TAPCELL_ROW_15_188 VGND VPWR sky130_fd_sc_hd__tapvpwrvgnd_1
X_0793_ _0563_/Y _0791_/C _0792_/X VGND VGND VPWR VPWR _1237_/D sky130_fd_sc_hd__a21oi_2
X_1276_ _1278_/CLK _1276_/D load_slew96/X VGND VGND VPWR VPWR _1276_/Q sky130_fd_sc_hd__dfrtp_2
XFILLER_51_200 VGND VGND VPWR VPWR sky130_fd_sc_hd__decap_3
XFILLER_51_277 VGND VGND VPWR VPWR sky130_fd_sc_hd__decap_3
XFILLER_51_299 VGND VGND VPWR VPWR sky130_fd_sc_hd__decap_3
Xfanout110 _1060_/B1 VGND VGND VPWR VPWR _1064_/B1 sky130_fd_sc_hd__clkdlybuf4s25_1
Xfanout121 _1027_/B1 VGND VGND VPWR VPWR _1036_/B1 sky130_fd_sc_hd__clkdlybuf4s25_1
XFILLER_27_263 VGND VGND VPWR VPWR sky130_fd_sc_hd__decap_3
XFILLER_47_45 VGND VGND VPWR VPWR sky130_fd_sc_hd__fill_2
XTAP_TAPCELL_ROW_29_258 VGND VPWR sky130_fd_sc_hd__tapvpwrvgnd_1
XFILLER_6_101 VGND VGND VPWR VPWR sky130_fd_sc_hd__decap_3
XTAP_TAPCELL_ROW_12_169 VGND VPWR sky130_fd_sc_hd__tapvpwrvgnd_1
XFILLER_6_156 VGND VGND VPWR VPWR sky130_fd_sc_hd__fill_2
X_1130_ _1268_/CLK _1130_/D _0978_/X VGND VGND VPWR VPWR _1130_/Q sky130_fd_sc_hd__dfrtp_2
X_1061_ _1061_/A1 _1061_/A2 _1061_/B1 VGND VGND VPWR VPWR _1061_/X sky130_fd_sc_hd__o21a_2
X_0914_ hold184/X _0678_/X _0904_/X _0913_/X VGND VGND VPWR VPWR _1116_/D sky130_fd_sc_hd__o22a_2
X_0845_ hold280/X _0696_/A _0860_/S VGND VGND VPWR VPWR _1074_/D sky130_fd_sc_hd__mux2_1
X_0776_ _1225_/Q _0777_/B VGND VGND VPWR VPWR _0778_/B sky130_fd_sc_hd__or2_2
XFILLER_24_200 VGND VGND VPWR VPWR sky130_fd_sc_hd__fill_1
X_1259_ _1259_/CLK _1259_/D _1067_/X VGND VGND VPWR VPWR _1259_/Q sky130_fd_sc_hd__dfrtp_2
XTAP_TAPCELL_ROW_3_126 VGND VPWR sky130_fd_sc_hd__tapvpwrvgnd_1
XFILLER_24_222 VGND VGND VPWR VPWR sky130_fd_sc_hd__decap_3
XFILLER_33_69 VGND VGND VPWR VPWR sky130_fd_sc_hd__fill_1
XTAP_TAPCELL_ROW_34_283 VGND VPWR sky130_fd_sc_hd__tapvpwrvgnd_1
XTAP_TAPCELL_ROW_26_239 VGND VPWR sky130_fd_sc_hd__tapvpwrvgnd_1
XFILLER_15_277 VGND VGND VPWR VPWR sky130_fd_sc_hd__decap_3
XFILLER_15_288 VGND VGND VPWR VPWR sky130_fd_sc_hd__decap_3
XFILLER_23_91 VGND VGND VPWR VPWR sky130_fd_sc_hd__decap_3
XFILLER_30_225 VGND VGND VPWR VPWR sky130_fd_sc_hd__decap_3
XFILLER_30_247 VGND VGND VPWR VPWR sky130_fd_sc_hd__decap_3
X_0630_ _0632_/B _0630_/B VGND VGND VPWR VPWR _1207_/D sky130_fd_sc_hd__nand2_2
X_0561_ _1220_/Q VGND VGND VPWR VPWR _0561_/Y sky130_fd_sc_hd__inv_2
XFILLER_17_3 VGND VGND VPWR VPWR sky130_fd_sc_hd__fill_1
X_1113_ clkload5/A _1113_/D fanout97/X VGND VGND VPWR VPWR _1113_/Q sky130_fd_sc_hd__dfrtp_2
X_1044_ _1053_/A1 _1053_/A2 _1049_/B1 VGND VGND VPWR VPWR _1044_/X sky130_fd_sc_hd__o21a_2
XTAP_TAPCELL_ROW_48_353 VGND VPWR sky130_fd_sc_hd__tapvpwrvgnd_1
XTAP_TAPCELL_ROW_0_107 VGND VPWR sky130_fd_sc_hd__tapvpwrvgnd_1
XFILLER_21_214 VGND VGND VPWR VPWR sky130_fd_sc_hd__fill_2
XFILLER_21_225 VGND VGND VPWR VPWR sky130_fd_sc_hd__decap_3
XFILLER_9_71 VGND VGND VPWR VPWR sky130_fd_sc_hd__decap_3
X_0828_ _1249_/Q _0824_/X hold258/X VGND VGND VPWR VPWR _0830_/A sky130_fd_sc_hd__a21oi_2
X_0759_ _1219_/Q _0759_/B VGND VGND VPWR VPWR _0760_/C sky130_fd_sc_hd__or2_2
XTAP_TAPCELL_ROW_31_264 VGND VPWR sky130_fd_sc_hd__tapvpwrvgnd_1
XFILLER_28_58 VGND VGND VPWR VPWR sky130_fd_sc_hd__fill_2
XTAP_TAPCELL_ROW_22_220 VGND VPWR sky130_fd_sc_hd__tapvpwrvgnd_1
XFILLER_5_18 VGND VGND VPWR VPWR sky130_fd_sc_hd__fill_1
XFILLER_35_306 VGND VGND VPWR VPWR sky130_fd_sc_hd__fill_2
XFILLER_47_111 VGND VGND VPWR VPWR sky130_fd_sc_hd__fill_1
XFILLER_47_144 VGND VGND VPWR VPWR sky130_fd_sc_hd__decap_3
XFILLER_47_199 VGND VGND VPWR VPWR sky130_fd_sc_hd__decap_3
XTAP_TAPCELL_ROW_45_334 VGND VPWR sky130_fd_sc_hd__tapvpwrvgnd_1
Xhold207 _0819_/X VGND VGND VPWR VPWR _1246_/D sky130_fd_sc_hd__dlygate4sd3_1
Xhold218 _1271_/Q VGND VGND VPWR VPWR hold218/X sky130_fd_sc_hd__dlygate4sd3_1
Xhold229 _0964_/X VGND VGND VPWR VPWR _1268_/D sky130_fd_sc_hd__dlygate4sd3_1
X_0613_ _1212_/D VGND VGND VPWR VPWR _0613_/Y sky130_fd_sc_hd__inv_2
X_0544_ _1081_/Q VGND VGND VPWR VPWR _0617_/B sky130_fd_sc_hd__inv_2
XFILLER_38_144 VGND VGND VPWR VPWR sky130_fd_sc_hd__decap_3
X_1027_ _1027_/A1 _1027_/A2 _1027_/B1 VGND VGND VPWR VPWR _1027_/X sky130_fd_sc_hd__o21a_2
XFILLER_14_49 VGND VGND VPWR VPWR sky130_fd_sc_hd__decap_3
XFILLER_30_26 VGND VGND VPWR VPWR sky130_fd_sc_hd__fill_2
XFILLER_17_306 VGND VGND VPWR VPWR sky130_fd_sc_hd__fill_2
XFILLER_29_111 VGND VGND VPWR VPWR sky130_fd_sc_hd__fill_1
XFILLER_29_177 VGND VGND VPWR VPWR sky130_fd_sc_hd__decap_3
XFILLER_39_57 VGND VGND VPWR VPWR sky130_fd_sc_hd__decap_3
XFILLER_35_169 VGND VGND VPWR VPWR sky130_fd_sc_hd__decap_3
XFILLER_50_106 VGND VGND VPWR VPWR sky130_fd_sc_hd__decap_3
XFILLER_50_139 VGND VGND VPWR VPWR sky130_fd_sc_hd__fill_1
XFILLER_26_158 VGND VGND VPWR VPWR sky130_fd_sc_hd__fill_2
XFILLER_41_106 VGND VGND VPWR VPWR sky130_fd_sc_hd__decap_3
XFILLER_1_246 VGND VGND VPWR VPWR sky130_fd_sc_hd__fill_1
XFILLER_1_279 VGND VGND VPWR VPWR sky130_fd_sc_hd__fill_1
XFILLER_49_217 VGND VGND VPWR VPWR sky130_fd_sc_hd__decap_3
XFILLER_49_228 VGND VGND VPWR VPWR sky130_fd_sc_hd__decap_3
XFILLER_17_169 VGND VGND VPWR VPWR sky130_fd_sc_hd__fill_2
XFILLER_40_172 VGND VGND VPWR VPWR sky130_fd_sc_hd__decap_3
XFILLER_31_91 VGND VGND VPWR VPWR sky130_fd_sc_hd__decap_3
XFILLER_23_106 VGND VGND VPWR VPWR sky130_fd_sc_hd__decap_3
XFILLER_48_283 VGND VGND VPWR VPWR sky130_fd_sc_hd__decap_3
XFILLER_31_172 VGND VGND VPWR VPWR sky130_fd_sc_hd__decap_3
XFILLER_36_25 VGND VGND VPWR VPWR sky130_fd_sc_hd__decap_3
XFILLER_39_250 VGND VGND VPWR VPWR sky130_fd_sc_hd__decap_3
XFILLER_46_209 VGND VGND VPWR VPWR sky130_fd_sc_hd__decap_3
XTAP_TAPCELL_ROW_9_154 VGND VPWR sky130_fd_sc_hd__tapvpwrvgnd_1
XFILLER_13_172 VGND VGND VPWR VPWR sky130_fd_sc_hd__decap_3
XFILLER_42_90 VGND VGND VPWR VPWR sky130_fd_sc_hd__decap_3
X_0930_ _0930_/A _0930_/B VGND VGND VPWR VPWR _1119_/D sky130_fd_sc_hd__nor2_2
X_0861_ hold269/X input8/X _0861_/S VGND VGND VPWR VPWR _1089_/D sky130_fd_sc_hd__mux2_1
X_0792_ _1236_/Q _1235_/Q _1237_/Q _0815_/A VGND VGND VPWR VPWR _0792_/X sky130_fd_sc_hd__a31o_2
XFILLER_47_3 VGND VGND VPWR VPWR sky130_fd_sc_hd__decap_3
XFILLER_36_253 VGND VGND VPWR VPWR sky130_fd_sc_hd__decap_3
X_1275_ clkload4/A _1275_/D fanout103/X VGND VGND VPWR VPWR _1275_/Q sky130_fd_sc_hd__dfrtp_2
XFILLER_11_109 VGND VGND VPWR VPWR sky130_fd_sc_hd__decap_3
XFILLER_51_212 VGND VGND VPWR VPWR sky130_fd_sc_hd__decap_3
XFILLER_51_234 VGND VGND VPWR VPWR sky130_fd_sc_hd__decap_3
XFILLER_51_256 VGND VGND VPWR VPWR sky130_fd_sc_hd__decap_3
XFILLER_22_27 VGND VGND VPWR VPWR sky130_fd_sc_hd__fill_1
Xfanout100 _1017_/B1 VGND VGND VPWR VPWR fanout98/A sky130_fd_sc_hd__clkdlybuf4s25_1
Xfanout111 _1060_/B1 VGND VGND VPWR VPWR _1019_/B1 sky130_fd_sc_hd__clkdlybuf4s25_1
Xfanout122 _1034_/B1 VGND VGND VPWR VPWR _1027_/B1 sky130_fd_sc_hd__clkdlybuf4s25_1
XFILLER_47_57 VGND VGND VPWR VPWR sky130_fd_sc_hd__fill_2
XPHY_EDGE_ROW_29_Right_29 VGND VGND VPWR VPWR sky130_fd_sc_hd__decap_3
XPHY_EDGE_ROW_38_Right_38 VGND VGND VPWR VPWR sky130_fd_sc_hd__decap_3
XFILLER_8_29 VGND VGND VPWR VPWR sky130_fd_sc_hd__fill_2
XFILLER_8_18 VGND VGND VPWR VPWR sky130_fd_sc_hd__decap_3
XFILLER_18_220 VGND VGND VPWR VPWR sky130_fd_sc_hd__decap_3
Xclkbuf_2_0__f_i_clk clkbuf_0_i_clk/X VGND VGND VPWR VPWR clkbuf_leaf_2_i_clk/A sky130_fd_sc_hd__clkbuf_16
X_1060_ _1063_/A1 _1063_/A2 _1060_/B1 VGND VGND VPWR VPWR _1060_/X sky130_fd_sc_hd__o21a_2
XPHY_EDGE_ROW_47_Right_47 VGND VGND VPWR VPWR sky130_fd_sc_hd__decap_3
XPHY_EDGE_ROW_25_Left_77 VGND VGND VPWR VPWR sky130_fd_sc_hd__decap_3
XFILLER_18_253 VGND VGND VPWR VPWR sky130_fd_sc_hd__decap_3
XFILLER_33_256 VGND VGND VPWR VPWR sky130_fd_sc_hd__decap_3
XFILLER_33_289 VGND VGND VPWR VPWR sky130_fd_sc_hd__decap_3
X_0913_ _1074_/Q input41/X _0917_/S VGND VGND VPWR VPWR _0913_/X sky130_fd_sc_hd__mux2_1
X_0844_ hold277/X _0693_/A _0860_/S VGND VGND VPWR VPWR _1073_/D sky130_fd_sc_hd__mux2_1
X_0775_ hold198/X _0771_/C _0774_/Y VGND VGND VPWR VPWR _1224_/D sky130_fd_sc_hd__o21a_2
XFILLER_24_234 VGND VGND VPWR VPWR sky130_fd_sc_hd__decap_3
X_1258_ _1259_/CLK _1258_/D _1066_/X VGND VGND VPWR VPWR _1258_/Q sky130_fd_sc_hd__dfrtp_2
X_1189_ _1236_/CLK _1189_/D _1061_/B1 VGND VGND VPWR VPWR _1189_/Q sky130_fd_sc_hd__dfrtp_2
XTAP_TAPCELL_ROW_3_127 VGND VPWR sky130_fd_sc_hd__tapvpwrvgnd_1
XFILLER_24_267 VGND VGND VPWR VPWR sky130_fd_sc_hd__decap_3
XFILLER_33_48 VGND VGND VPWR VPWR sky130_fd_sc_hd__decap_3
XFILLER_30_259 VGND VGND VPWR VPWR sky130_fd_sc_hd__fill_2
XFILLER_2_160 VGND VGND VPWR VPWR sky130_fd_sc_hd__fill_1
XFILLER_31_6 VGND VGND VPWR VPWR sky130_fd_sc_hd__fill_1
XFILLER_38_304 VGND VGND VPWR VPWR sky130_fd_sc_hd__decap_3
X_0560_ _1219_/Q VGND VGND VPWR VPWR _0560_/Y sky130_fd_sc_hd__inv_2
XFILLER_0_63 VGND VGND VPWR VPWR sky130_fd_sc_hd__fill_1
XFILLER_0_85 VGND VGND VPWR VPWR sky130_fd_sc_hd__decap_3
X_1112_ clkload5/A _1112_/D fanout97/X VGND VGND VPWR VPWR _1112_/Q sky130_fd_sc_hd__dfrtp_2
X_1043_ _1061_/A1 _1061_/A2 _1055_/B1 VGND VGND VPWR VPWR _1043_/X sky130_fd_sc_hd__o21a_2
XTAP_TAPCELL_ROW_0_108 VGND VPWR sky130_fd_sc_hd__tapvpwrvgnd_1
XTAP_TAPCELL_ROW_31_265 VGND VPWR sky130_fd_sc_hd__tapvpwrvgnd_1
X_0827_ _1249_/Q _0824_/X _0826_/Y VGND VGND VPWR VPWR _1249_/D sky130_fd_sc_hd__o21a_2
X_0758_ _1219_/Q _0759_/B VGND VGND VPWR VPWR _0760_/B sky130_fd_sc_hd__nand2_2
X_0689_ _0689_/A _1076_/Q VGND VGND VPWR VPWR _0689_/Y sky130_fd_sc_hd__nand2_2
XFILLER_12_204 VGND VGND VPWR VPWR sky130_fd_sc_hd__decap_3
XFILLER_12_226 VGND VGND VPWR VPWR sky130_fd_sc_hd__decap_3
XFILLER_44_58 VGND VGND VPWR VPWR sky130_fd_sc_hd__fill_1
XFILLER_12_259 VGND VGND VPWR VPWR sky130_fd_sc_hd__decap_3
XFILLER_20_270 VGND VGND VPWR VPWR sky130_fd_sc_hd__decap_3
XFILLER_20_292 VGND VGND VPWR VPWR sky130_fd_sc_hd__decap_3
XTAP_TAPCELL_ROW_22_221 VGND VPWR sky130_fd_sc_hd__tapvpwrvgnd_1
XFILLER_47_156 VGND VGND VPWR VPWR sky130_fd_sc_hd__decap_3
XFILLER_47_178 VGND VGND VPWR VPWR sky130_fd_sc_hd__decap_3
XTAP_TAPCELL_ROW_45_335 VGND VPWR sky130_fd_sc_hd__tapvpwrvgnd_1
Xhold208 _1274_/Q VGND VGND VPWR VPWR _0615_/A sky130_fd_sc_hd__dlygate4sd3_1
Xhold219 _0967_/X VGND VGND VPWR VPWR _1271_/D sky130_fd_sc_hd__dlygate4sd3_1
X_0612_ _0612_/A _0648_/A VGND VGND VPWR VPWR _1212_/D sky130_fd_sc_hd__nor2_2
XFILLER_7_263 VGND VGND VPWR VPWR sky130_fd_sc_hd__fill_1
X_0543_ _0974_/S VGND VGND VPWR VPWR _0543_/Y sky130_fd_sc_hd__inv_2
XFILLER_38_156 VGND VGND VPWR VPWR sky130_fd_sc_hd__decap_3
XFILLER_38_178 VGND VGND VPWR VPWR sky130_fd_sc_hd__decap_3
X_1026_ _1027_/A1 _1027_/A2 _1027_/B1 VGND VGND VPWR VPWR _1026_/X sky130_fd_sc_hd__o21a_2
XPHY_EDGE_ROW_28_Left_80 VGND VGND VPWR VPWR sky130_fd_sc_hd__decap_3
XPHY_EDGE_ROW_12_Left_64 VGND VGND VPWR VPWR sky130_fd_sc_hd__decap_3
XFILLER_29_167 VGND VGND VPWR VPWR sky130_fd_sc_hd__fill_1
XFILLER_44_148 VGND VGND VPWR VPWR sky130_fd_sc_hd__fill_1
XTAP_TAPCELL_ROW_50_360 VGND VPWR sky130_fd_sc_hd__tapvpwrvgnd_1
XFILLER_35_137 VGND VGND VPWR VPWR sky130_fd_sc_hd__decap_3
X_1009_ _1017_/A1 _1017_/A2 _1016_/B1 VGND VGND VPWR VPWR _1009_/X sky130_fd_sc_hd__o21a_2
XFILLER_1_214 VGND VGND VPWR VPWR sky130_fd_sc_hd__fill_1
XFILLER_9_6 VGND VGND VPWR VPWR sky130_fd_sc_hd__decap_3
XFILLER_15_60 VGND VGND VPWR VPWR sky130_fd_sc_hd__decap_3
XFILLER_25_181 VGND VGND VPWR VPWR sky130_fd_sc_hd__decap_3
XFILLER_9_303 VGND VGND VPWR VPWR sky130_fd_sc_hd__decap_3
XFILLER_48_251 VGND VGND VPWR VPWR sky130_fd_sc_hd__fill_1
XFILLER_48_262 VGND VGND VPWR VPWR sky130_fd_sc_hd__decap_3
XFILLER_48_295 VGND VGND VPWR VPWR sky130_fd_sc_hd__decap_3
XFILLER_31_184 VGND VGND VPWR VPWR sky130_fd_sc_hd__decap_3
XFILLER_39_262 VGND VGND VPWR VPWR sky130_fd_sc_hd__decap_3
XFILLER_39_284 VGND VGND VPWR VPWR sky130_fd_sc_hd__decap_3
XFILLER_22_151 VGND VGND VPWR VPWR sky130_fd_sc_hd__decap_3
XFILLER_22_195 VGND VGND VPWR VPWR sky130_fd_sc_hd__fill_1
XTAP_TAPCELL_ROW_9_155 VGND VPWR sky130_fd_sc_hd__tapvpwrvgnd_1
XFILLER_7_3 VGND VGND VPWR VPWR sky130_fd_sc_hd__decap_3
X_0860_ hold268/X input7/X _0860_/S VGND VGND VPWR VPWR _1088_/D sky130_fd_sc_hd__mux2_1
X_0791_ _0804_/A _0791_/B _0791_/C VGND VGND VPWR VPWR _1236_/D sky130_fd_sc_hd__and3_2
XFILLER_36_243 VGND VGND VPWR VPWR sky130_fd_sc_hd__decap_3
X_1274_ clkload4/A _1274_/D fanout103/X VGND VGND VPWR VPWR _1274_/Q sky130_fd_sc_hd__dfrtp_2
XFILLER_51_246 VGND VGND VPWR VPWR sky130_fd_sc_hd__decap_3
XFILLER_51_268 VGND VGND VPWR VPWR sky130_fd_sc_hd__decap_3
X_0989_ _1038_/A1 _1038_/A2 _1020_/B1 VGND VGND VPWR VPWR _0989_/X sky130_fd_sc_hd__o21a_2
Xfanout101 fanout106/X VGND VGND VPWR VPWR fanout101/X sky130_fd_sc_hd__clkdlybuf4s25_1
Xfanout112 _1017_/B1 VGND VGND VPWR VPWR _1060_/B1 sky130_fd_sc_hd__clkdlybuf4s25_1
Xfanout123 input28/X VGND VGND VPWR VPWR _1034_/B1 sky130_fd_sc_hd__clkdlybuf4s25_1
XFILLER_27_254 VGND VGND VPWR VPWR sky130_fd_sc_hd__decap_3
XFILLER_42_224 VGND VGND VPWR VPWR sky130_fd_sc_hd__decap_3
XFILLER_10_132 VGND VGND VPWR VPWR sky130_fd_sc_hd__fill_1
XFILLER_12_72 VGND VGND VPWR VPWR sky130_fd_sc_hd__decap_3
XFILLER_6_147 VGND VGND VPWR VPWR sky130_fd_sc_hd__decap_3
XPHY_EDGE_ROW_0_Left_52 VGND VGND VPWR VPWR sky130_fd_sc_hd__decap_3
XFILLER_18_232 VGND VGND VPWR VPWR sky130_fd_sc_hd__decap_3
XFILLER_18_265 VGND VGND VPWR VPWR sky130_fd_sc_hd__decap_3
X_0912_ hold189/X _0678_/X _0904_/X _0911_/X VGND VGND VPWR VPWR _1115_/D sky130_fd_sc_hd__o22a_2
X_0843_ hold276/X _0690_/A _0860_/S VGND VGND VPWR VPWR _1072_/D sky130_fd_sc_hd__mux2_1
X_0774_ _0774_/A _0777_/B VGND VGND VPWR VPWR _0774_/Y sky130_fd_sc_hd__nor2_2
XTAP_TAPCELL_ROW_3_128 VGND VPWR sky130_fd_sc_hd__tapvpwrvgnd_1
X_1257_ _1259_/CLK _1257_/D _1065_/X VGND VGND VPWR VPWR _1257_/Q sky130_fd_sc_hd__dfrtp_2
X_1188_ clkload4/A _1188_/D fanout105/X VGND VGND VPWR VPWR _1188_/Q sky130_fd_sc_hd__dfrtp_2
XFILLER_24_279 VGND VGND VPWR VPWR sky130_fd_sc_hd__fill_2
XPHY_EDGE_ROW_42_Left_94 VGND VGND VPWR VPWR sky130_fd_sc_hd__decap_3
XFILLER_47_305 VGND VGND VPWR VPWR sky130_fd_sc_hd__decap_3
XFILLER_23_60 VGND VGND VPWR VPWR sky130_fd_sc_hd__fill_1
XFILLER_23_82 VGND VGND VPWR VPWR sky130_fd_sc_hd__decap_3
XFILLER_2_194 VGND VGND VPWR VPWR sky130_fd_sc_hd__fill_2
X_1111_ _1191_/CLK _1111_/D load_slew102/X VGND VGND VPWR VPWR _1111_/Q sky130_fd_sc_hd__dfrtp_2
X_1042_ _1042_/A1 _1042_/A2 _1042_/B1 VGND VGND VPWR VPWR _1042_/X sky130_fd_sc_hd__o21a_2
XTAP_TAPCELL_ROW_0_109 VGND VPWR sky130_fd_sc_hd__tapvpwrvgnd_1
XTAP_TAPCELL_ROW_31_266 VGND VPWR sky130_fd_sc_hd__tapvpwrvgnd_1
X_0826_ _1249_/Q _0824_/X _0815_/A VGND VGND VPWR VPWR _0826_/Y sky130_fd_sc_hd__a21oi_2
X_0757_ _0559_/Y _0755_/B _0759_/B _0774_/A VGND VGND VPWR VPWR _1218_/D sky130_fd_sc_hd__a211oi_2
X_0688_ _0689_/A _1076_/Q VGND VGND VPWR VPWR _0688_/X sky130_fd_sc_hd__or2_2
XFILLER_44_26 VGND VGND VPWR VPWR sky130_fd_sc_hd__fill_2
XTAP_TAPCELL_ROW_22_222 VGND VPWR sky130_fd_sc_hd__tapvpwrvgnd_1
XFILLER_47_113 VGND VGND VPWR VPWR sky130_fd_sc_hd__decap_3
XTAP_TAPCELL_ROW_45_336 VGND VPWR sky130_fd_sc_hd__tapvpwrvgnd_1
XFILLER_11_271 VGND VGND VPWR VPWR sky130_fd_sc_hd__fill_2
XFILLER_7_220 VGND VGND VPWR VPWR sky130_fd_sc_hd__decap_3
XFILLER_50_80 VGND VGND VPWR VPWR sky130_fd_sc_hd__decap_3
Xhold209 _0893_/X VGND VGND VPWR VPWR _1106_/D sky130_fd_sc_hd__dlygate4sd3_1
X_0611_ _0891_/A _0611_/B VGND VGND VPWR VPWR _1253_/D sky130_fd_sc_hd__and2_2
X_0542_ _1161_/Q VGND VGND VPWR VPWR _0542_/Y sky130_fd_sc_hd__inv_2
XFILLER_22_3 VGND VGND VPWR VPWR sky130_fd_sc_hd__decap_3
X_1025_ _1027_/A1 _1027_/A2 _1027_/B1 VGND VGND VPWR VPWR _1025_/X sky130_fd_sc_hd__o21a_2
X_0809_ _1243_/Q _0824_/A _0824_/B VGND VGND VPWR VPWR _0814_/C sky130_fd_sc_hd__and3_2
XFILLER_29_102 VGND VGND VPWR VPWR sky130_fd_sc_hd__fill_2
XFILLER_29_113 VGND VGND VPWR VPWR sky130_fd_sc_hd__decap_3
XFILLER_44_138 VGND VGND VPWR VPWR sky130_fd_sc_hd__fill_2
XFILLER_40_300 VGND VGND VPWR VPWR sky130_fd_sc_hd__decap_3
XTAP_TAPCELL_ROW_50_361 VGND VPWR sky130_fd_sc_hd__tapvpwrvgnd_1
XFILLER_45_80 VGND VGND VPWR VPWR sky130_fd_sc_hd__decap_3
XFILLER_34_171 VGND VGND VPWR VPWR sky130_fd_sc_hd__decap_3
X_1008_ _1019_/A1 _1019_/A2 _1060_/B1 VGND VGND VPWR VPWR _1008_/X sky130_fd_sc_hd__o21a_2
XFILLER_1_204 VGND VGND VPWR VPWR sky130_fd_sc_hd__fill_2
XFILLER_49_208 VGND VGND VPWR VPWR sky130_fd_sc_hd__decap_3
XFILLER_13_300 VGND VGND VPWR VPWR sky130_fd_sc_hd__decap_3
XFILLER_31_60 VGND VGND VPWR VPWR sky130_fd_sc_hd__fill_2
Xoutput60 _1192_/Q VGND VGND VPWR VPWR o_start_ack sky130_fd_sc_hd__clkdlybuf4s25_1
XFILLER_48_230 VGND VGND VPWR VPWR sky130_fd_sc_hd__decap_3
XFILLER_48_274 VGND VGND VPWR VPWR sky130_fd_sc_hd__decap_3
X_1290_ _1290_/A _0610_/X VGND VGND VPWR VPWR io_sda sky130_fd_sc_hd__ebufn_2
XTAP_TAPCELL_ROW_18_199 VGND VPWR sky130_fd_sc_hd__tapvpwrvgnd_1
XFILLER_39_274 VGND VGND VPWR VPWR sky130_fd_sc_hd__fill_1
XFILLER_39_296 VGND VGND VPWR VPWR sky130_fd_sc_hd__decap_3
XFILLER_22_141 VGND VGND VPWR VPWR sky130_fd_sc_hd__fill_1
XTAP_TAPCELL_ROW_9_156 VGND VPWR sky130_fd_sc_hd__tapvpwrvgnd_1
XFILLER_45_222 VGND VGND VPWR VPWR sky130_fd_sc_hd__fill_2
XFILLER_45_233 VGND VGND VPWR VPWR sky130_fd_sc_hd__decap_3
XFILLER_13_141 VGND VGND VPWR VPWR sky130_fd_sc_hd__decap_3
XFILLER_45_255 VGND VGND VPWR VPWR sky130_fd_sc_hd__decap_3
XFILLER_45_277 VGND VGND VPWR VPWR sky130_fd_sc_hd__decap_3
XFILLER_45_288 VGND VGND VPWR VPWR sky130_fd_sc_hd__decap_3
XFILLER_42_70 VGND VGND VPWR VPWR sky130_fd_sc_hd__decap_3
X_0790_ _1236_/Q _1235_/Q VGND VGND VPWR VPWR _0791_/C sky130_fd_sc_hd__nand2_2
X_1273_ _1278_/CLK _1273_/D fanout97/X VGND VGND VPWR VPWR _1273_/Q sky130_fd_sc_hd__dfrtp_2
XFILLER_36_222 VGND VGND VPWR VPWR sky130_fd_sc_hd__decap_3
XFILLER_51_203 VGND VGND VPWR VPWR sky130_fd_sc_hd__decap_3
XFILLER_51_225 VGND VGND VPWR VPWR sky130_fd_sc_hd__decap_3
X_0988_ _1019_/A1 _1019_/A2 _1019_/B1 VGND VGND VPWR VPWR _0988_/X sky130_fd_sc_hd__o21a_2
XTAP_TAPCELL_ROW_14_180 VGND VPWR sky130_fd_sc_hd__tapvpwrvgnd_1
Xfanout113 input28/X VGND VGND VPWR VPWR _1017_/B1 sky130_fd_sc_hd__clkdlybuf4s25_1
XFILLER_27_222 VGND VGND VPWR VPWR sky130_fd_sc_hd__fill_2
Xfanout124 _1061_/B1 VGND VGND VPWR VPWR _1040_/B1 sky130_fd_sc_hd__clkdlybuf4s25_1
XTAP_TAPCELL_ROW_37_294 VGND VPWR sky130_fd_sc_hd__tapvpwrvgnd_1
XFILLER_10_111 VGND VGND VPWR VPWR sky130_fd_sc_hd__decap_3
XFILLER_50_280 VGND VGND VPWR VPWR sky130_fd_sc_hd__decap_3
XFILLER_6_104 VGND VGND VPWR VPWR sky130_fd_sc_hd__decap_3
XFILLER_18_211 VGND VGND VPWR VPWR sky130_fd_sc_hd__decap_3
XFILLER_37_70 VGND VGND VPWR VPWR sky130_fd_sc_hd__decap_3
XTAP_TAPCELL_ROW_28_250 VGND VPWR sky130_fd_sc_hd__tapvpwrvgnd_1
X_0911_ _1073_/Q input40/X _0917_/S VGND VGND VPWR VPWR _0911_/X sky130_fd_sc_hd__mux2_1
X_0842_ hold267/X _0687_/A _0860_/S VGND VGND VPWR VPWR _1071_/D sky130_fd_sc_hd__mux2_1
X_0773_ _0780_/A _0780_/B _0780_/C VGND VGND VPWR VPWR _0777_/B sky130_fd_sc_hd__and3_2
X_1256_ _1268_/CLK _1256_/D _1064_/X VGND VGND VPWR VPWR _1256_/Q sky130_fd_sc_hd__dfrtp_2
XFILLER_24_225 VGND VGND VPWR VPWR sky130_fd_sc_hd__decap_3
X_1187_ _1227_/CLK _1187_/D fanout120/X VGND VGND VPWR VPWR _1187_/Q sky130_fd_sc_hd__dfrtp_2
XFILLER_15_214 VGND VGND VPWR VPWR sky130_fd_sc_hd__fill_2
XFILLER_15_225 VGND VGND VPWR VPWR sky130_fd_sc_hd__decap_3
XFILLER_30_228 VGND VGND VPWR VPWR sky130_fd_sc_hd__decap_3
XFILLER_30_239 VGND VGND VPWR VPWR sky130_fd_sc_hd__fill_1
XFILLER_23_94 VGND VGND VPWR VPWR sky130_fd_sc_hd__decap_3
X_1110_ clkload4/A _1110_/D _1042_/B1 VGND VGND VPWR VPWR _1110_/Q sky130_fd_sc_hd__dfrtp_2
X_1041_ _1042_/A1 _1042_/A2 _1042_/B1 VGND VGND VPWR VPWR _1041_/X sky130_fd_sc_hd__o21a_2
X_0825_ _0567_/Y _0822_/C _0824_/X _0815_/A VGND VGND VPWR VPWR _1248_/D sky130_fd_sc_hd__a211oi_2
XTAP_TAPCELL_ROW_31_267 VGND VPWR sky130_fd_sc_hd__tapvpwrvgnd_1
XFILLER_9_85 VGND VGND VPWR VPWR sky130_fd_sc_hd__decap_3
XFILLER_9_74 VGND VGND VPWR VPWR sky130_fd_sc_hd__decap_3
X_0756_ _1217_/Q _1218_/Q _0780_/A VGND VGND VPWR VPWR _0759_/B sky130_fd_sc_hd__and3_2
X_0687_ _0687_/A _1071_/Q VGND VGND VPWR VPWR _0687_/X sky130_fd_sc_hd__or2_2
X_1239_ clkload9/A _1239_/D _1047_/X VGND VGND VPWR VPWR _1239_/Q sky130_fd_sc_hd__dfrtp_2
XFILLER_12_217 VGND VGND VPWR VPWR sky130_fd_sc_hd__decap_3
XTAP_TAPCELL_ROW_22_223 VGND VPWR sky130_fd_sc_hd__tapvpwrvgnd_1
XFILLER_20_261 VGND VGND VPWR VPWR sky130_fd_sc_hd__decap_3
XFILLER_47_147 VGND VGND VPWR VPWR sky130_fd_sc_hd__decap_3
XTAP_TAPCELL_ROW_45_337 VGND VPWR sky130_fd_sc_hd__tapvpwrvgnd_1
Xload_slew102 fanout101/X VGND VGND VPWR VPWR load_slew102/X sky130_fd_sc_hd__clkbuf_4
X_0610_ _1230_/Q _1252_/Q _1196_/Q _1097_/Q VGND VGND VPWR VPWR _0610_/X sky130_fd_sc_hd__and4_2
X_0541_ input9/X VGND VGND VPWR VPWR _1201_/D sky130_fd_sc_hd__inv_2
XFILLER_15_3 VGND VGND VPWR VPWR sky130_fd_sc_hd__decap_3
XFILLER_38_147 VGND VGND VPWR VPWR sky130_fd_sc_hd__fill_1
X_1024_ _1027_/A1 _1027_/A2 _1027_/B1 VGND VGND VPWR VPWR _1024_/X sky130_fd_sc_hd__o21a_2
X_0808_ _0824_/A _0824_/B _1243_/Q VGND VGND VPWR VPWR _0810_/B sky130_fd_sc_hd__a21oi_2
X_0739_ _0738_/X _0970_/S _0739_/S VGND VGND VPWR VPWR _1188_/D sky130_fd_sc_hd__mux2_1
XFILLER_29_169 VGND VGND VPWR VPWR sky130_fd_sc_hd__fill_1
XTAP_TAPCELL_ROW_50_362 VGND VPWR sky130_fd_sc_hd__tapvpwrvgnd_1
XFILLER_35_128 VGND VGND VPWR VPWR sky130_fd_sc_hd__decap_3
XFILLER_31_301 VGND VGND VPWR VPWR sky130_fd_sc_hd__decap_3
XFILLER_43_172 VGND VGND VPWR VPWR sky130_fd_sc_hd__decap_3
XFILLER_50_109 VGND VGND VPWR VPWR sky130_fd_sc_hd__fill_2
XFILLER_19_191 VGND VGND VPWR VPWR sky130_fd_sc_hd__decap_3
XFILLER_25_18 VGND VGND VPWR VPWR sky130_fd_sc_hd__decap_3
XFILLER_41_109 VGND VGND VPWR VPWR sky130_fd_sc_hd__decap_3
X_1007_ _1063_/A1 _1063_/A2 _1040_/B1 VGND VGND VPWR VPWR _1007_/X sky130_fd_sc_hd__o21a_2
XFILLER_15_51 VGND VGND VPWR VPWR sky130_fd_sc_hd__decap_3
XFILLER_31_94 VGND VGND VPWR VPWR sky130_fd_sc_hd__decap_3
XFILLER_40_197 VGND VGND VPWR VPWR sky130_fd_sc_hd__fill_2
Xoutput61 _1186_/Q VGND VGND VPWR VPWR o_transmit_data_request sky130_fd_sc_hd__clkdlybuf4s25_1
Xoutput50 _0540_/Y VGND VGND VPWR VPWR o_int_n sky130_fd_sc_hd__clkdlybuf4s25_1
XFILLER_23_109 VGND VGND VPWR VPWR sky130_fd_sc_hd__decap_3
XFILLER_48_242 VGND VGND VPWR VPWR sky130_fd_sc_hd__decap_3
XFILLER_48_253 VGND VGND VPWR VPWR sky130_fd_sc_hd__decap_3
XFILLER_48_286 VGND VGND VPWR VPWR sky130_fd_sc_hd__decap_3
XFILLER_31_175 VGND VGND VPWR VPWR sky130_fd_sc_hd__decap_3
XFILLER_39_253 VGND VGND VPWR VPWR sky130_fd_sc_hd__decap_3
XFILLER_22_197 VGND VGND VPWR VPWR sky130_fd_sc_hd__decap_3
XTAP_TAPCELL_ROW_9_157 VGND VPWR sky130_fd_sc_hd__tapvpwrvgnd_1
XFILLER_45_201 VGND VGND VPWR VPWR sky130_fd_sc_hd__fill_2
XFILLER_13_131 VGND VGND VPWR VPWR sky130_fd_sc_hd__fill_2
XFILLER_13_164 VGND VGND VPWR VPWR sky130_fd_sc_hd__decap_3
XFILLER_13_175 VGND VGND VPWR VPWR sky130_fd_sc_hd__fill_1
XFILLER_26_61 VGND VGND VPWR VPWR sky130_fd_sc_hd__decap_3
XFILLER_26_83 VGND VGND VPWR VPWR sky130_fd_sc_hd__fill_1
XFILLER_9_113 VGND VGND VPWR VPWR sky130_fd_sc_hd__decap_3
XFILLER_42_93 VGND VGND VPWR VPWR sky130_fd_sc_hd__decap_3
XFILLER_47_6 VGND VGND VPWR VPWR sky130_fd_sc_hd__fill_2
XFILLER_3_32 VGND VGND VPWR VPWR sky130_fd_sc_hd__decap_3
X_1272_ _1278_/CLK _1272_/D fanout97/X VGND VGND VPWR VPWR _1272_/Q sky130_fd_sc_hd__dfrtp_2
XFILLER_36_234 VGND VGND VPWR VPWR sky130_fd_sc_hd__decap_3
XFILLER_36_256 VGND VGND VPWR VPWR sky130_fd_sc_hd__decap_3
XFILLER_51_215 VGND VGND VPWR VPWR sky130_fd_sc_hd__decap_3
XFILLER_51_237 VGND VGND VPWR VPWR sky130_fd_sc_hd__decap_3
XFILLER_51_259 VGND VGND VPWR VPWR sky130_fd_sc_hd__decap_3
X_0987_ _1019_/A1 _1019_/A2 _1060_/B1 VGND VGND VPWR VPWR _0987_/X sky130_fd_sc_hd__o21a_2
XTAP_TAPCELL_ROW_14_181 VGND VPWR sky130_fd_sc_hd__tapvpwrvgnd_1
Xfanout103 fanout106/X VGND VGND VPWR VPWR fanout103/X sky130_fd_sc_hd__clkdlybuf4s25_1
Xfanout114 fanout120/X VGND VGND VPWR VPWR fanout114/X sky130_fd_sc_hd__clkdlybuf4s25_1
Xfanout125 _1061_/B1 VGND VGND VPWR VPWR _1067_/B1 sky130_fd_sc_hd__clkdlybuf4s25_1
XFILLER_50_292 VGND VGND VPWR VPWR sky130_fd_sc_hd__decap_3
XTAP_TAPCELL_ROW_37_295 VGND VPWR sky130_fd_sc_hd__tapvpwrvgnd_1
XFILLER_10_156 VGND VGND VPWR VPWR sky130_fd_sc_hd__decap_3
XFILLER_12_85 VGND VGND VPWR VPWR sky130_fd_sc_hd__fill_1
XFILLER_2_300 VGND VGND VPWR VPWR sky130_fd_sc_hd__decap_3
Xhold190 _1111_/Q VGND VGND VPWR VPWR hold190/X sky130_fd_sc_hd__dlygate4sd3_1
XFILLER_18_223 VGND VGND VPWR VPWR sky130_fd_sc_hd__decap_3
XFILLER_18_256 VGND VGND VPWR VPWR sky130_fd_sc_hd__decap_3
XFILLER_33_259 VGND VGND VPWR VPWR sky130_fd_sc_hd__decap_3
XTAP_TAPCELL_ROW_28_251 VGND VPWR sky130_fd_sc_hd__tapvpwrvgnd_1
XPHY_EDGE_ROW_16_Right_16 VGND VGND VPWR VPWR sky130_fd_sc_hd__decap_3
X_0910_ hold202/X _0677_/Y _0903_/Y _0909_/X VGND VGND VPWR VPWR _1114_/D sky130_fd_sc_hd__a22o_2
X_0841_ hold266/X _0692_/A _0860_/S VGND VGND VPWR VPWR _1070_/D sky130_fd_sc_hd__mux2_1
X_0772_ _1222_/Q _1221_/Q _1224_/Q _1223_/Q VGND VGND VPWR VPWR _0780_/C sky130_fd_sc_hd__and4_2
XPHY_EDGE_ROW_25_Right_25 VGND VGND VPWR VPWR sky130_fd_sc_hd__decap_3
X_1255_ _1268_/CLK _1255_/D _1063_/X VGND VGND VPWR VPWR _1255_/Q sky130_fd_sc_hd__dfrtp_2
X_1186_ _1191_/CLK _1186_/D fanout106/X VGND VGND VPWR VPWR _1186_/Q sky130_fd_sc_hd__dfrtp_2
XPHY_EDGE_ROW_34_Right_34 VGND VGND VPWR VPWR sky130_fd_sc_hd__decap_3
XFILLER_24_237 VGND VGND VPWR VPWR sky130_fd_sc_hd__fill_2
XPHY_EDGE_ROW_43_Right_43 VGND VGND VPWR VPWR sky130_fd_sc_hd__decap_3
XFILLER_15_259 VGND VGND VPWR VPWR sky130_fd_sc_hd__fill_1
XFILLER_23_292 VGND VGND VPWR VPWR sky130_fd_sc_hd__fill_1
XFILLER_2_130 VGND VGND VPWR VPWR sky130_fd_sc_hd__fill_1
XFILLER_2_141 VGND VGND VPWR VPWR sky130_fd_sc_hd__decap_3
XFILLER_38_307 VGND VGND VPWR VPWR sky130_fd_sc_hd__fill_1
X_1040_ _1042_/A1 _1042_/A2 _1040_/B1 VGND VGND VPWR VPWR _1040_/X sky130_fd_sc_hd__o21a_2
X_0824_ _0824_/A _0824_/B _0824_/C _0824_/D VGND VGND VPWR VPWR _0824_/X sky130_fd_sc_hd__and4_2
X_0755_ _0760_/A _0755_/B _0755_/C VGND VGND VPWR VPWR _1217_/D sky130_fd_sc_hd__and3_2
XTAP_TAPCELL_ROW_31_268 VGND VPWR sky130_fd_sc_hd__tapvpwrvgnd_1
X_0686_ _0687_/A _1071_/Q VGND VGND VPWR VPWR _0686_/Y sky130_fd_sc_hd__nand2_2
X_1238_ _1240_/CLK _1238_/D _1046_/X VGND VGND VPWR VPWR _1238_/Q sky130_fd_sc_hd__dfrtp_2
X_1169_ clkload4/A _1169_/D fanout105/X VGND VGND VPWR VPWR _1169_/Q sky130_fd_sc_hd__dfstp_2
XFILLER_12_207 VGND VGND VPWR VPWR sky130_fd_sc_hd__fill_2
XFILLER_12_229 VGND VGND VPWR VPWR sky130_fd_sc_hd__decap_3
XFILLER_20_295 VGND VGND VPWR VPWR sky130_fd_sc_hd__decap_3
XFILLER_47_159 VGND VGND VPWR VPWR sky130_fd_sc_hd__decap_3
XFILLER_34_72 VGND VGND VPWR VPWR sky130_fd_sc_hd__decap_3
XTAP_TAPCELL_ROW_45_338 VGND VPWR sky130_fd_sc_hd__tapvpwrvgnd_1
XFILLER_11_262 VGND VGND VPWR VPWR sky130_fd_sc_hd__decap_3
XFILLER_50_71 VGND VGND VPWR VPWR sky130_fd_sc_hd__decap_3
XFILLER_7_233 VGND VGND VPWR VPWR sky130_fd_sc_hd__fill_2
X_0540_ _1077_/Q VGND VGND VPWR VPWR _0540_/Y sky130_fd_sc_hd__inv_2
XFILLER_38_104 VGND VGND VPWR VPWR sky130_fd_sc_hd__decap_3
XFILLER_38_159 VGND VGND VPWR VPWR sky130_fd_sc_hd__fill_1
XFILLER_46_192 VGND VGND VPWR VPWR sky130_fd_sc_hd__decap_3
X_1023_ _1027_/A1 _1027_/A2 _1049_/B1 VGND VGND VPWR VPWR _1023_/X sky130_fd_sc_hd__o21a_2
X_0807_ _0566_/Y _0804_/B _0806_/X VGND VGND VPWR VPWR _1242_/D sky130_fd_sc_hd__a21oi_2
X_0738_ _1163_/Q _0542_/Y _1186_/Q _0666_/X VGND VGND VPWR VPWR _0738_/X sky130_fd_sc_hd__a31o_2
XFILLER_39_17 VGND VGND VPWR VPWR sky130_fd_sc_hd__decap_3
X_0669_ _0546_/Y hold197/X _1189_/D VGND VGND VPWR VPWR _1165_/D sky130_fd_sc_hd__a21o_2
XPHY_EDGE_ROW_2_Right_2 VGND VGND VPWR VPWR sky130_fd_sc_hd__decap_3
XFILLER_37_181 VGND VGND VPWR VPWR sky130_fd_sc_hd__decap_3
XTAP_TAPCELL_ROW_42_319 VGND VPWR sky130_fd_sc_hd__tapvpwrvgnd_1
XTAP_TAPCELL_ROW_50_363 VGND VPWR sky130_fd_sc_hd__tapvpwrvgnd_1
XFILLER_20_85 VGND VGND VPWR VPWR sky130_fd_sc_hd__fill_1
XFILLER_35_107 VGND VGND VPWR VPWR sky130_fd_sc_hd__decap_3
XFILLER_43_195 VGND VGND VPWR VPWR sky130_fd_sc_hd__decap_3
XFILLER_6_32 VGND VGND VPWR VPWR sky130_fd_sc_hd__fill_1
XFILLER_6_54 VGND VGND VPWR VPWR sky130_fd_sc_hd__fill_1
XPHY_EDGE_ROW_16_Left_68 VGND VGND VPWR VPWR sky130_fd_sc_hd__decap_3
X_1006_ _1063_/A1 _1063_/A2 _1060_/B1 VGND VGND VPWR VPWR _1006_/X sky130_fd_sc_hd__o21a_2
XFILLER_34_195 VGND VGND VPWR VPWR sky130_fd_sc_hd__fill_1
XFILLER_9_9 VGND VGND VPWR VPWR sky130_fd_sc_hd__decap_3
XFILLER_15_63 VGND VGND VPWR VPWR sky130_fd_sc_hd__decap_3
XFILLER_25_184 VGND VGND VPWR VPWR sky130_fd_sc_hd__decap_3
XFILLER_40_132 VGND VGND VPWR VPWR sky130_fd_sc_hd__fill_1
XFILLER_9_306 VGND VGND VPWR VPWR sky130_fd_sc_hd__fill_2
XFILLER_48_221 VGND VGND VPWR VPWR sky130_fd_sc_hd__decap_3
Xclkbuf_2_3__f_i_clk clkbuf_0_i_clk/X VGND VGND VPWR VPWR clkload2/A sky130_fd_sc_hd__clkbuf_16
Xoutput51 _1098_/Q VGND VGND VPWR VPWR o_receive_data[0] sky130_fd_sc_hd__clkdlybuf4s25_1
XFILLER_48_265 VGND VGND VPWR VPWR sky130_fd_sc_hd__decap_3
XFILLER_48_298 VGND VGND VPWR VPWR sky130_fd_sc_hd__decap_3
XFILLER_31_187 VGND VGND VPWR VPWR sky130_fd_sc_hd__fill_2
XFILLER_39_210 VGND VGND VPWR VPWR sky130_fd_sc_hd__decap_3
XFILLER_39_265 VGND VGND VPWR VPWR sky130_fd_sc_hd__decap_3
XFILLER_39_287 VGND VGND VPWR VPWR sky130_fd_sc_hd__decap_3
XFILLER_10_305 VGND VGND VPWR VPWR sky130_fd_sc_hd__decap_3
XTAP_TAPCELL_ROW_9_158 VGND VPWR sky130_fd_sc_hd__tapvpwrvgnd_1
XFILLER_7_6 VGND VGND VPWR VPWR sky130_fd_sc_hd__decap_3
XFILLER_45_246 VGND VGND VPWR VPWR sky130_fd_sc_hd__decap_3
XFILLER_42_61 VGND VGND VPWR VPWR sky130_fd_sc_hd__decap_3
XFILLER_36_213 VGND VGND VPWR VPWR sky130_fd_sc_hd__decap_3
X_1271_ _1278_/CLK _1271_/D load_slew96/X VGND VGND VPWR VPWR _1271_/Q sky130_fd_sc_hd__dfrtp_2
XFILLER_36_246 VGND VGND VPWR VPWR sky130_fd_sc_hd__decap_3
XFILLER_51_249 VGND VGND VPWR VPWR sky130_fd_sc_hd__decap_3
X_0986_ _1019_/A1 _1019_/A2 _1019_/B1 VGND VGND VPWR VPWR _0986_/X sky130_fd_sc_hd__o21a_2
XTAP_TAPCELL_ROW_14_182 VGND VPWR sky130_fd_sc_hd__tapvpwrvgnd_1
XFILLER_8_180 VGND VGND VPWR VPWR sky130_fd_sc_hd__decap_3
Xfanout126 _1055_/B1 VGND VGND VPWR VPWR _1049_/B1 sky130_fd_sc_hd__clkdlybuf4s25_1
XTAP_TAPCELL_ROW_6_139 VGND VPWR sky130_fd_sc_hd__tapvpwrvgnd_1
XFILLER_27_257 VGND VGND VPWR VPWR sky130_fd_sc_hd__decap_3
XFILLER_42_205 VGND VGND VPWR VPWR sky130_fd_sc_hd__decap_3
XFILLER_42_227 VGND VGND VPWR VPWR sky130_fd_sc_hd__fill_1
XPHY_EDGE_ROW_19_Left_71 VGND VGND VPWR VPWR sky130_fd_sc_hd__decap_3
XFILLER_50_271 VGND VGND VPWR VPWR sky130_fd_sc_hd__decap_3
XTAP_TAPCELL_ROW_37_296 VGND VPWR sky130_fd_sc_hd__tapvpwrvgnd_1
XFILLER_5_3 VGND VGND VPWR VPWR sky130_fd_sc_hd__fill_1
XFILLER_6_128 VGND VGND VPWR VPWR sky130_fd_sc_hd__fill_1
Xhold180 _1095_/Q VGND VGND VPWR VPWR hold180/X sky130_fd_sc_hd__dlygate4sd3_1
Xhold191 _1149_/Q VGND VGND VPWR VPWR hold191/X sky130_fd_sc_hd__dlygate4sd3_1
XFILLER_18_235 VGND VGND VPWR VPWR sky130_fd_sc_hd__decap_3
XFILLER_18_268 VGND VGND VPWR VPWR sky130_fd_sc_hd__fill_1
XTAP_TAPCELL_ROW_28_252 VGND VPWR sky130_fd_sc_hd__tapvpwrvgnd_1
X_0840_ _1036_/A1 _1036_/A2 _1049_/B1 VGND VGND VPWR VPWR _0840_/X sky130_fd_sc_hd__o21a_2
X_0771_ _0774_/A _0771_/B _0771_/C VGND VGND VPWR VPWR _1223_/D sky130_fd_sc_hd__nor3_2
XFILLER_38_3 VGND VGND VPWR VPWR sky130_fd_sc_hd__decap_3
XFILLER_5_172 VGND VGND VPWR VPWR sky130_fd_sc_hd__decap_3
X_1254_ clkload8/A _1254_/D _1062_/X VGND VGND VPWR VPWR _1254_/Q sky130_fd_sc_hd__dfrtp_2
X_1185_ _1192_/CLK _1185_/D fanout116/X VGND VGND VPWR VPWR _1185_/Q sky130_fd_sc_hd__dfrtp_2
XFILLER_17_290 VGND VGND VPWR VPWR sky130_fd_sc_hd__decap_3
X_0969_ hold249/X hold247/X _0974_/S VGND VGND VPWR VPWR _1273_/D sky130_fd_sc_hd__mux2_1
XTAP_TAPCELL_ROW_2_120 VGND VPWR sky130_fd_sc_hd__tapvpwrvgnd_1
XPHY_EDGE_ROW_4_Left_56 VGND VGND VPWR VPWR sky130_fd_sc_hd__decap_3
XFILLER_23_52 VGND VGND VPWR VPWR sky130_fd_sc_hd__decap_3
XFILLER_23_85 VGND VGND VPWR VPWR sky130_fd_sc_hd__decap_3
XFILLER_48_71 VGND VGND VPWR VPWR sky130_fd_sc_hd__decap_3
XFILLER_14_271 VGND VGND VPWR VPWR sky130_fd_sc_hd__decap_3
XFILLER_9_65 VGND VGND VPWR VPWR sky130_fd_sc_hd__decap_3
XFILLER_9_21 VGND VGND VPWR VPWR sky130_fd_sc_hd__decap_3
X_0823_ _1248_/Q _1247_/Q VGND VGND VPWR VPWR _0824_/D sky130_fd_sc_hd__and2_2
X_0754_ _1217_/Q _0780_/A VGND VGND VPWR VPWR _0755_/C sky130_fd_sc_hd__or2_2
X_0685_ hold282/X _0557_/Y _1198_/D VGND VGND VPWR VPWR _1171_/D sky130_fd_sc_hd__a21o_2
XFILLER_49_190 VGND VGND VPWR VPWR sky130_fd_sc_hd__decap_3
X_1237_ _1240_/CLK _1237_/D _1045_/X VGND VGND VPWR VPWR _1237_/Q sky130_fd_sc_hd__dfrtp_2
X_1168_ clkload4/A _1168_/D _1020_/B1 VGND VGND VPWR VPWR _1168_/Q sky130_fd_sc_hd__dfrtp_2
X_1099_ _1119_/CLK _1099_/D VGND VGND VPWR VPWR _1099_/Q sky130_fd_sc_hd__dfxtp_2
XPHY_EDGE_ROW_46_Left_98 VGND VGND VPWR VPWR sky130_fd_sc_hd__decap_3
XFILLER_18_52 VGND VGND VPWR VPWR sky130_fd_sc_hd__decap_3
XFILLER_18_85 VGND VGND VPWR VPWR sky130_fd_sc_hd__decap_3
XFILLER_47_116 VGND VGND VPWR VPWR sky130_fd_sc_hd__decap_3
XFILLER_50_50 VGND VGND VPWR VPWR sky130_fd_sc_hd__decap_3
XFILLER_50_83 VGND VGND VPWR VPWR sky130_fd_sc_hd__fill_1
XFILLER_7_223 VGND VGND VPWR VPWR sky130_fd_sc_hd__fill_1
Xload_slew115 fanout114/X VGND VGND VPWR VPWR load_slew115/X sky130_fd_sc_hd__clkbuf_2
Xload_slew104 fanout103/X VGND VGND VPWR VPWR _1020_/B1 sky130_fd_sc_hd__buf_2
X_1022_ _1027_/A1 _1027_/A2 _1049_/B1 VGND VGND VPWR VPWR _1022_/X sky130_fd_sc_hd__o21a_2
X_0806_ _0824_/A _0824_/B _0815_/A VGND VGND VPWR VPWR _0806_/X sky130_fd_sc_hd__a21o_2
X_0737_ _0674_/X _0556_/Y _0737_/S VGND VGND VPWR VPWR _1194_/D sky130_fd_sc_hd__mux2_1
X_0668_ _0555_/Y hold238/X _1160_/Q VGND VGND VPWR VPWR _1189_/D sky130_fd_sc_hd__o21a_2
XFILLER_29_116 VGND VGND VPWR VPWR sky130_fd_sc_hd__decap_3
X_0599_ _1140_/Q _1131_/Q _1132_/Q VGND VGND VPWR VPWR _0600_/C sky130_fd_sc_hd__a21o_2
XFILLER_40_303 VGND VGND VPWR VPWR sky130_fd_sc_hd__decap_3
XFILLER_4_204 VGND VGND VPWR VPWR sky130_fd_sc_hd__decap_3
XFILLER_20_53 VGND VGND VPWR VPWR sky130_fd_sc_hd__fill_2
XFILLER_28_193 VGND VGND VPWR VPWR sky130_fd_sc_hd__decap_3
XFILLER_45_83 VGND VGND VPWR VPWR sky130_fd_sc_hd__fill_2
XFILLER_19_182 VGND VGND VPWR VPWR sky130_fd_sc_hd__decap_3
XFILLER_22_303 VGND VGND VPWR VPWR sky130_fd_sc_hd__decap_3
XFILLER_34_141 VGND VGND VPWR VPWR sky130_fd_sc_hd__fill_1
X_1005_ _1063_/A1 _1063_/A2 _1060_/B1 VGND VGND VPWR VPWR _1005_/X sky130_fd_sc_hd__o21a_2
XFILLER_13_303 VGND VGND VPWR VPWR sky130_fd_sc_hd__decap_3
XFILLER_15_42 VGND VGND VPWR VPWR sky130_fd_sc_hd__decap_3
XFILLER_15_97 VGND VGND VPWR VPWR sky130_fd_sc_hd__decap_3
Xoutput52 _1099_/Q VGND VGND VPWR VPWR o_receive_data[1] sky130_fd_sc_hd__clkdlybuf4s25_1
XPHY_EDGE_ROW_33_Left_85 VGND VGND VPWR VPWR sky130_fd_sc_hd__decap_3
XFILLER_48_200 VGND VGND VPWR VPWR sky130_fd_sc_hd__decap_3
XFILLER_48_233 VGND VGND VPWR VPWR sky130_fd_sc_hd__decap_3
XFILLER_48_277 VGND VGND VPWR VPWR sky130_fd_sc_hd__decap_3
XFILLER_31_100 VGND VGND VPWR VPWR sky130_fd_sc_hd__decap_3
.ends
